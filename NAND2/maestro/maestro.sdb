ADE simulation setup
Run mode: Single Run, Sweeps and Corners
Tests:
  ECE4740_S25_inv_1_1: ECE4740_S25/inv_1/schematic, simulator spectre
    Variables: voff = 0
