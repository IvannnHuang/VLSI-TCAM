`include "constants.vams"
`include "disciplines.vams"

module tcam_driver (
  in1, in2, preW, write, WL, SL1, SL2, preML, vdd, gnd
);

  output [31:0] in1, in2, SL1, SL2;
  electrical [31:0] in1, in2, SL1, SL2;

  output [31:0] WL, preML;
  electrical [31:0] WL, preML;

  output preW, write;
  electrical preW, write;

  (* inh_conn_prop_name = "gnd", inh_conn_def_value = "cds_globals.\\gnd!" *) inout gnd;
  electrical gnd;
  (* inh_conn_prop_name = "vdd", inh_conn_def_value = "cds_globals.\\vdd!" *) inout vdd;
  electrical vdd;

  parameter real v_high = 1.0;
  parameter real v_low = 0.0;
  parameter real trise = 10p;

  parameter real TpreW_dur = 390p;
  parameter real T_dur = 90p;
  parameter real Twrite_dur = 690p;
  parameter real TWL_dur = 690p;
  parameter real T_row_cycle = 1n;

  parameter real Tsearch_start = 32n;
  parameter real Tsearch_dur   = 1n;
  parameter real TpreML_dur    = 490p;

parameter integer row0_value_left  = 252645135;
parameter integer row1_value_left  = 252645135;
parameter integer row2_value_left  = 252645135;
parameter integer row3_value_left  = 252645135;
parameter integer row4_value_left  = 252645135;
parameter integer row5_value_left  = 252645135;
parameter integer row6_value_left  = 252645135;
parameter integer row7_value_left  = 252645135;
parameter integer row8_value_left  = 252645135;
parameter integer row9_value_left  = 252645135;
parameter integer row10_value_left = 252645135;
parameter integer row11_value_left = 252645135;
parameter integer row12_value_left = 252645135;
parameter integer row13_value_left = 252645135;
parameter integer row14_value_left = 252645135;
parameter integer row15_value_left = 252645135;
parameter integer row16_value_left = 252645135;
parameter integer row17_value_left = 252645135;
parameter integer row18_value_left = 252645135;
parameter integer row19_value_left = 252645135;
parameter integer row20_value_left = 252645135;
parameter integer row21_value_left = 252645135;
parameter integer row22_value_left = 252645135;
parameter integer row23_value_left = 252645135;
parameter integer row24_value_left = 252645135;
parameter integer row25_value_left = 252645135;
parameter integer row26_value_left = 252645135;
parameter integer row27_value_left = 252645135;
parameter integer row28_value_left = 252645135;
parameter integer row29_value_left = 252645135;
parameter integer row31_value_left = 252645135;
parameter integer row30_value_left = 2863311530;  // different pattern

parameter integer row0_value_right  = 4042322160;
parameter integer row1_value_right  = 4042322160;
parameter integer row2_value_right  = 4042322160;
parameter integer row3_value_right  = 4042322160;
parameter integer row4_value_right  = 4042322160;
parameter integer row5_value_right  = 4042322160;
parameter integer row6_value_right  = 4042322160;
parameter integer row7_value_right  = 4042322160;
parameter integer row8_value_right  = 4042322160;
parameter integer row9_value_right  = 4042322160;
parameter integer row10_value_right = 4042322160;
parameter integer row11_value_right = 4042322160;
parameter integer row12_value_right = 4042322160;
parameter integer row13_value_right = 4042322160;
parameter integer row14_value_right = 4042322160;
parameter integer row15_value_right = 4042322160;
parameter integer row16_value_right = 4042322160;
parameter integer row17_value_right = 4042322160;
parameter integer row18_value_right = 4042322160;
parameter integer row19_value_right = 4042322160;
parameter integer row20_value_right = 4042322160;
parameter integer row21_value_right = 4042322160;
parameter integer row22_value_right = 4042322160;
parameter integer row23_value_right = 4042322160;
parameter integer row24_value_right = 4042322160;
parameter integer row25_value_right = 4042322160;
parameter integer row26_value_right = 4042322160;
parameter integer row27_value_right = 4042322160;
parameter integer row28_value_right = 4042322160;
parameter integer row29_value_right = 4042322160;
parameter integer row31_value_right = 4042322160;
parameter integer row30_value_right = 1431655765;  // complement of different pattern

parameter integer search_value_left  = 2863311530;
parameter integer search_value_right = 1431655765;

    real preW_val;
  analog begin

	// perW low to high before every write rising edge
	V(preW) <+ transition(
   	 (($abstime >= 0n     && $abstime < 0n     + TpreW_dur) ||
     ($abstime >= 1n     && $abstime < 1n     + TpreW_dur) ||
     ($abstime >= 2n     && $abstime < 2n     + TpreW_dur) ||
     ($abstime >= 3n     && $abstime < 3n     + TpreW_dur) ||
     ($abstime >= 4n     && $abstime < 4n     + TpreW_dur) ||
     ($abstime >= 5n     && $abstime < 5n     + TpreW_dur) ||
     ($abstime >= 6n     && $abstime < 6n     + TpreW_dur) ||
     ($abstime >= 7n     && $abstime < 7n     + TpreW_dur) ||
     ($abstime >= 8n     && $abstime < 8n     + TpreW_dur) ||
     ($abstime >= 9n     && $abstime < 9n     + TpreW_dur) ||
     ($abstime >= 10n    && $abstime < 10n    + TpreW_dur) ||
     ($abstime >= 11n    && $abstime < 11n    + TpreW_dur) ||
     ($abstime >= 12n    && $abstime < 12n    + TpreW_dur) ||
     ($abstime >= 13n    && $abstime < 13n    + TpreW_dur) ||
     ($abstime >= 14n    && $abstime < 14n    + TpreW_dur) ||
     ($abstime >= 15n    && $abstime < 15n    + TpreW_dur) ||
     ($abstime >= 16n    && $abstime < 16n    + TpreW_dur) ||
     ($abstime >= 17n    && $abstime < 17n    + TpreW_dur) ||
     ($abstime >= 18n    && $abstime < 18n    + TpreW_dur) ||
     ($abstime >= 19n    && $abstime < 19n    + TpreW_dur) ||
     ($abstime >= 20n    && $abstime < 20n    + TpreW_dur) ||
     ($abstime >= 21n    && $abstime < 21n    + TpreW_dur) ||
     ($abstime >= 22n    && $abstime < 22n    + TpreW_dur) ||
     ($abstime >= 23n    && $abstime < 23n    + TpreW_dur) ||
     ($abstime >= 24n    && $abstime < 24n    + TpreW_dur) ||
     ($abstime >= 25n    && $abstime < 25n    + TpreW_dur) ||
     ($abstime >= 26n    && $abstime < 26n    + TpreW_dur) ||
     ($abstime >= 27n    && $abstime < 27n    + TpreW_dur) ||
     ($abstime >= 28n    && $abstime < 28n    + TpreW_dur) ||
     ($abstime >= 29n    && $abstime < 29n    + TpreW_dur) ||
     ($abstime >= 30n    && $abstime < 30n    + TpreW_dur) ||
     ($abstime >= 31n    && $abstime < 31n    + TpreW_dur))
    ? v_low : v_high,
    0, trise);

    // Row 0
    V(write) <+ transition(($abstime >= 0n + T_dur && $abstime < 0n + Twrite_dur) ? v_high : v_low, 0, trise);
    V(WL[0]) <+ transition(($abstime >= 0n + T_dur && $abstime < 0n + TWL_dur) ? v_high : v_low, 0, trise);
	V(in1[0]) <+ transition(($abstime >= 0n + T_dur && $abstime < 0n + Twrite_dur) ?
                	((row0_value_left >> 0) & 1 ? v_high : v_low) : v_low, 0, trise);
	V(in2[0]) <+ transition(($abstime >= 0n + T_dur && $abstime < 0n + Twrite_dur) ?
                	((row0_value_right >> 0) & 1 ? v_high : v_low) : v_low, 0, trise);
	V(in1[1]) <+ transition(($abstime >= 0n + T_dur && $abstime < 0n + Twrite_dur) ?
                	((row0_value_left >> 1) & 1 ? v_high : v_low) : v_low, 0, trise);
	V(in2[1]) <+ transition(($abstime >= 0n + T_dur && $abstime < 0n + Twrite_dur) ?
                	((row0_value_right >> 1) & 1 ? v_high : v_low) : v_low, 0, trise);
	V(in1[2]) <+ transition(($abstime >= 0n + T_dur && $abstime < 0n + Twrite_dur) ?
                	((row0_value_left >> 2) & 1 ? v_high : v_low) : v_low, 0, trise);
	V(in2[2]) <+ transition(($abstime >= 0n + T_dur && $abstime < 0n + Twrite_dur) ?
                	((row0_value_right >> 2) & 1 ? v_high : v_low) : v_low, 0, trise);
	V(in1[3]) <+ transition(($abstime >= 0n + T_dur && $abstime < 0n + Twrite_dur) ?
                	((row0_value_left >> 3) & 1 ? v_high : v_low) : v_low, 0, trise);
	V(in2[3]) <+ transition(($abstime >= 0n + T_dur && $abstime < 0n + Twrite_dur) ?
                	((row0_value_right >> 3) & 1 ? v_high : v_low) : v_low, 0, trise);
	V(in1[4]) <+ transition(($abstime >= 0n + T_dur && $abstime < 0n + Twrite_dur) ?
                	((row0_value_left >> 4) & 1 ? v_high : v_low) : v_low, 0, trise);
	V(in2[4]) <+ transition(($abstime >= 0n + T_dur && $abstime < 0n + Twrite_dur) ?
                	((row0_value_right >> 4) & 1 ? v_high : v_low) : v_low, 0, trise);
	V(in1[5]) <+ transition(($abstime >= 0n + T_dur && $abstime < 0n + Twrite_dur) ?
                	((row0_value_left >> 5) & 1 ? v_high : v_low) : v_low, 0, trise);
	V(in2[5]) <+ transition(($abstime >= 0n + T_dur && $abstime < 0n + Twrite_dur) ?
                	((row0_value_right >> 5) & 1 ? v_high : v_low) : v_low, 0, trise);
	V(in1[6]) <+ transition(($abstime >= 0n + T_dur && $abstime < 0n + Twrite_dur) ?
                	((row0_value_left >> 6) & 1 ? v_high : v_low) : v_low, 0, trise);
	V(in2[6]) <+ transition(($abstime >= 0n + T_dur && $abstime < 0n + Twrite_dur) ?
                	((row0_value_right >> 6) & 1 ? v_high : v_low) : v_low, 0, trise);
	V(in1[7]) <+ transition(($abstime >= 0n + T_dur && $abstime < 0n + Twrite_dur) ?
                	((row0_value_left >> 7) & 1 ? v_high : v_low) : v_low, 0, trise);
	V(in2[7]) <+ transition(($abstime >= 0n + T_dur && $abstime < 0n + Twrite_dur) ?
                	((row0_value_right >> 7) & 1 ? v_high : v_low) : v_low, 0, trise);
	V(in1[8]) <+ transition(($abstime >= 0n + T_dur && $abstime < 0n + Twrite_dur) ?
                	((row0_value_left >> 8) & 1 ? v_high : v_low) : v_low, 0, trise);
	V(in2[8]) <+ transition(($abstime >= 0n + T_dur && $abstime < 0n + Twrite_dur) ?
                	((row0_value_right >> 8) & 1 ? v_high : v_low) : v_low, 0, trise);
	V(in1[9]) <+ transition(($abstime >= 0n + T_dur && $abstime < 0n + Twrite_dur) ?
                	((row0_value_left >> 9) & 1 ? v_high : v_low) : v_low, 0, trise);
	V(in2[9]) <+ transition(($abstime >= 0n + T_dur && $abstime < 0n + Twrite_dur) ?
                	((row0_value_right >> 9) & 1 ? v_high : v_low) : v_low, 0, trise);
	V(in1[10]) <+ transition(($abstime >= 0n + T_dur && $abstime < 0n + Twrite_dur) ?
                	((row0_value_left >> 10) & 1 ? v_high : v_low) : v_low, 0, trise);
	V(in2[10]) <+ transition(($abstime >= 0n + T_dur && $abstime < 0n + Twrite_dur) ?
                	((row0_value_right >> 10) & 1 ? v_high : v_low) : v_low, 0, trise);
	V(in1[11]) <+ transition(($abstime >= 0n + T_dur && $abstime < 0n + Twrite_dur) ?
                	((row0_value_left >> 11) & 1 ? v_high : v_low) : v_low, 0, trise);
	V(in2[11]) <+ transition(($abstime >= 0n + T_dur && $abstime < 0n + Twrite_dur) ?
                	((row0_value_right >> 11) & 1 ? v_high : v_low) : v_low, 0, trise);
	V(in1[12]) <+ transition(($abstime >= 0n + T_dur && $abstime < 0n + Twrite_dur) ?
                	((row0_value_left >> 12) & 1 ? v_high : v_low) : v_low, 0, trise);
	V(in2[12]) <+ transition(($abstime >= 0n + T_dur && $abstime < 0n + Twrite_dur) ?
                	((row0_value_right >> 12) & 1 ? v_high : v_low) : v_low, 0, trise);
	V(in1[13]) <+ transition(($abstime >= 0n + T_dur && $abstime < 0n + Twrite_dur) ?
                	((row0_value_left >> 13) & 1 ? v_high : v_low) : v_low, 0, trise);
	V(in2[13]) <+ transition(($abstime >= 0n + T_dur && $abstime < 0n + Twrite_dur) ?
                	((row0_value_right >> 13) & 1 ? v_high : v_low) : v_low, 0, trise);
	V(in1[14]) <+ transition(($abstime >= 0n + T_dur && $abstime < 0n + Twrite_dur) ?
                	((row0_value_left >> 14) & 1 ? v_high : v_low) : v_low, 0, trise);
	V(in2[14]) <+ transition(($abstime >= 0n + T_dur && $abstime < 0n + Twrite_dur) ?
                	((row0_value_right >> 14) & 1 ? v_high : v_low) : v_low, 0, trise);
	V(in1[15]) <+ transition(($abstime >= 0n + T_dur && $abstime < 0n + Twrite_dur) ?
                	((row0_value_left >> 15) & 1 ? v_high : v_low) : v_low, 0, trise);
	V(in2[15]) <+ transition(($abstime >= 0n + T_dur && $abstime < 0n + Twrite_dur) ?
                	((row0_value_right >> 15) & 1 ? v_high : v_low) : v_low, 0, trise);
	V(in1[16]) <+ transition(($abstime >= 0n + T_dur && $abstime < 0n + Twrite_dur) ?
                	((row0_value_left >> 16) & 1 ? v_high : v_low) : v_low, 0, trise);
	V(in2[16]) <+ transition(($abstime >= 0n + T_dur && $abstime < 0n + Twrite_dur) ?
                	((row0_value_right >> 16) & 1 ? v_high : v_low) : v_low, 0, trise);
	V(in1[17]) <+ transition(($abstime >= 0n + T_dur && $abstime < 0n + Twrite_dur) ?
                	((row0_value_left >> 17) & 1 ? v_high : v_low) : v_low, 0, trise);
	V(in2[17]) <+ transition(($abstime >= 0n + T_dur && $abstime < 0n + Twrite_dur) ?
                	((row0_value_right >> 17) & 1 ? v_high : v_low) : v_low, 0, trise);
	V(in1[18]) <+ transition(($abstime >= 0n + T_dur && $abstime < 0n + Twrite_dur) ?
                	((row0_value_left >> 18) & 1 ? v_high : v_low) : v_low, 0, trise);
	V(in2[18]) <+ transition(($abstime >= 0n + T_dur && $abstime < 0n + Twrite_dur) ?
                	((row0_value_right >> 18) & 1 ? v_high : v_low) : v_low, 0, trise);
	V(in1[19]) <+ transition(($abstime >= 0n + T_dur && $abstime < 0n + Twrite_dur) ?
                	((row0_value_left >> 19) & 1 ? v_high : v_low) : v_low, 0, trise);
	V(in2[19]) <+ transition(($abstime >= 0n + T_dur && $abstime < 0n + Twrite_dur) ?
                	((row0_value_right >> 19) & 1 ? v_high : v_low) : v_low, 0, trise);
	V(in1[20]) <+ transition(($abstime >= 0n + T_dur && $abstime < 0n + Twrite_dur) ?
                	((row0_value_left >> 20) & 1 ? v_high : v_low) : v_low, 0, trise);
	V(in2[20]) <+ transition(($abstime >= 0n + T_dur && $abstime < 0n + Twrite_dur) ?
                	((row0_value_right >> 20) & 1 ? v_high : v_low) : v_low, 0, trise);
	V(in1[21]) <+ transition(($abstime >= 0n + T_dur && $abstime < 0n + Twrite_dur) ?
                	((row0_value_left >> 21) & 1 ? v_high : v_low) : v_low, 0, trise);
	V(in2[21]) <+ transition(($abstime >= 0n + T_dur && $abstime < 0n + Twrite_dur) ?
                	((row0_value_right >> 21) & 1 ? v_high : v_low) : v_low, 0, trise);
	V(in1[22]) <+ transition(($abstime >= 0n + T_dur && $abstime < 0n + Twrite_dur) ?
                	((row0_value_left >> 22) & 1 ? v_high : v_low) : v_low, 0, trise);
	V(in2[22]) <+ transition(($abstime >= 0n + T_dur && $abstime < 0n + Twrite_dur) ?
                	((row0_value_right >> 22) & 1 ? v_high : v_low) : v_low, 0, trise);
	V(in1[23]) <+ transition(($abstime >= 0n + T_dur && $abstime < 0n + Twrite_dur) ?
                	((row0_value_left >> 23) & 1 ? v_high : v_low) : v_low, 0, trise);
	V(in2[23]) <+ transition(($abstime >= 0n + T_dur && $abstime < 0n + Twrite_dur) ?
                	((row0_value_right >> 23) & 1 ? v_high : v_low) : v_low, 0, trise);
	V(in1[24]) <+ transition(($abstime >= 0n + T_dur && $abstime < 0n + Twrite_dur) ?
                	((row0_value_left >> 24) & 1 ? v_high : v_low) : v_low, 0, trise);
	V(in2[24]) <+ transition(($abstime >= 0n + T_dur && $abstime < 0n + Twrite_dur) ?
                	((row0_value_right >> 24) & 1 ? v_high : v_low) : v_low, 0, trise);
	V(in1[25]) <+ transition(($abstime >= 0n + T_dur && $abstime < 0n + Twrite_dur) ?
                	((row0_value_left >> 25) & 1 ? v_high : v_low) : v_low, 0, trise);
	V(in2[25]) <+ transition(($abstime >= 0n + T_dur && $abstime < 0n + Twrite_dur) ?
                	((row0_value_right >> 25) & 1 ? v_high : v_low) : v_low, 0, trise);
	V(in1[26]) <+ transition(($abstime >= 0n + T_dur && $abstime < 0n + Twrite_dur) ?
                	((row0_value_left >> 26) & 1 ? v_high : v_low) : v_low, 0, trise);
	V(in2[26]) <+ transition(($abstime >= 0n + T_dur && $abstime < 0n + Twrite_dur) ?
                	((row0_value_right >> 26) & 1 ? v_high : v_low) : v_low, 0, trise);
	V(in1[27]) <+ transition(($abstime >= 0n + T_dur && $abstime < 0n + Twrite_dur) ?
                	((row0_value_left >> 27) & 1 ? v_high : v_low) : v_low, 0, trise);
	V(in2[27]) <+ transition(($abstime >= 0n + T_dur && $abstime < 0n + Twrite_dur) ?
                	((row0_value_right >> 27) & 1 ? v_high : v_low) : v_low, 0, trise);
	V(in1[28]) <+ transition(($abstime >= 0n + T_dur && $abstime < 0n + Twrite_dur) ?
                	((row0_value_left >> 28) & 1 ? v_high : v_low) : v_low, 0, trise);
	V(in2[28]) <+ transition(($abstime >= 0n + T_dur && $abstime < 0n + Twrite_dur) ?
                	((row0_value_right >> 28) & 1 ? v_high : v_low) : v_low, 0, trise);
	V(in1[29]) <+ transition(($abstime >= 0n + T_dur && $abstime < 0n + Twrite_dur) ?
                	((row0_value_left >> 29) & 1 ? v_high : v_low) : v_low, 0, trise);
	V(in2[29]) <+ transition(($abstime >= 0n + T_dur && $abstime < 0n + Twrite_dur) ?
                	((row0_value_right >> 29) & 1 ? v_high : v_low) : v_low, 0, trise);
	V(in1[30]) <+ transition(($abstime >= 0n + T_dur && $abstime < 0n + Twrite_dur) ?
                	((row0_value_left >> 30) & 1 ? v_high : v_low) : v_low, 0, trise);
	V(in2[30]) <+ transition(($abstime >= 0n + T_dur && $abstime < 0n + Twrite_dur) ?
                	((row0_value_right >> 30) & 1 ? v_high : v_low) : v_low, 0, trise);
	V(in1[31]) <+ transition(($abstime >= 0n + T_dur && $abstime < 0n + Twrite_dur) ?
                	((row0_value_left >> 31) & 1 ? v_high : v_low) : v_low, 0, trise);
	V(in2[31]) <+ transition(($abstime >= 0n + T_dur && $abstime < 0n + Twrite_dur) ?
                	((row0_value_right >> 31) & 1 ? v_high : v_low) : v_low, 0, trise);

    V(write) <+ transition(($abstime >= 1n + T_dur && $abstime < 1n + Twrite_dur) ? v_high : v_low, 0, trise);
    V(WL[1]) <+ transition(($abstime >= 1n + T_dur && $abstime < 1n + TWL_dur) ? v_high : v_low, 0, trise);
	V(in1[0]) <+ transition(($abstime >= 1n + T_dur && $abstime < 1n + Twrite_dur) ?
                    ((row1_value_left >> 0) & 1 ? v_high : v_low) : v_low, 0, trise);
	V(in2[0]) <+ transition(($abstime >= 1n + T_dur && $abstime < 1n + Twrite_dur) ?
                    ((row1_value_right >> 0) & 1 ? v_high : v_low) : v_low, 0, trise);
	V(in1[1]) <+ transition(($abstime >= 1n + T_dur && $abstime < 1n + Twrite_dur) ?
                    ((row1_value_left >> 1) & 1 ? v_high : v_low) : v_low, 0, trise);
	V(in2[1]) <+ transition(($abstime >= 1n + T_dur && $abstime < 1n + Twrite_dur) ?
                    ((row1_value_right >> 1) & 1 ? v_high : v_low) : v_low, 0, trise);
	V(in1[2]) <+ transition(($abstime >= 1n + T_dur && $abstime < 1n + Twrite_dur) ?
                    ((row1_value_left >> 2) & 1 ? v_high : v_low) : v_low, 0, trise);
	V(in2[2]) <+ transition(($abstime >= 1n + T_dur && $abstime < 1n + Twrite_dur) ?
                    ((row1_value_right >> 2) & 1 ? v_high : v_low) : v_low, 0, trise);
	V(in1[3]) <+ transition(($abstime >= 1n + T_dur && $abstime < 1n + Twrite_dur) ?
                    ((row1_value_left >> 3) & 1 ? v_high : v_low) : v_low, 0, trise);
	V(in2[3]) <+ transition(($abstime >= 1n + T_dur && $abstime < 1n + Twrite_dur) ?
                    ((row1_value_right >> 3) & 1 ? v_high : v_low) : v_low, 0, trise);
	V(in1[4]) <+ transition(($abstime >= 1n + T_dur && $abstime < 1n + Twrite_dur) ?
                    ((row1_value_left >> 4) & 1 ? v_high : v_low) : v_low, 0, trise);
	V(in2[4]) <+ transition(($abstime >= 1n + T_dur && $abstime < 1n + Twrite_dur) ?
                    ((row1_value_right >> 4) & 1 ? v_high : v_low) : v_low, 0, trise);
	V(in1[5]) <+ transition(($abstime >= 1n + T_dur && $abstime < 1n + Twrite_dur) ?
                    ((row1_value_left >> 5) & 1 ? v_high : v_low) : v_low, 0, trise);
	V(in2[5]) <+ transition(($abstime >= 1n + T_dur && $abstime < 1n + Twrite_dur) ?
                    ((row1_value_right >> 5) & 1 ? v_high : v_low) : v_low, 0, trise);
	V(in1[6]) <+ transition(($abstime >= 1n + T_dur && $abstime < 1n + Twrite_dur) ?
                    ((row1_value_left >> 6) & 1 ? v_high : v_low) : v_low, 0, trise);
	V(in2[6]) <+ transition(($abstime >= 1n + T_dur && $abstime < 1n + Twrite_dur) ?
                    ((row1_value_right >> 6) & 1 ? v_high : v_low) : v_low, 0, trise);
	V(in1[7]) <+ transition(($abstime >= 1n + T_dur && $abstime < 1n + Twrite_dur) ?
                    ((row1_value_left >> 7) & 1 ? v_high : v_low) : v_low, 0, trise);
	V(in2[7]) <+ transition(($abstime >= 1n + T_dur && $abstime < 1n + Twrite_dur) ?
                    ((row1_value_right >> 7) & 1 ? v_high : v_low) : v_low, 0, trise);
	V(in1[8]) <+ transition(($abstime >= 1n + T_dur && $abstime < 1n + Twrite_dur) ?
                    ((row1_value_left >> 8) & 1 ? v_high : v_low) : v_low, 0, trise);
	V(in2[8]) <+ transition(($abstime >= 1n + T_dur && $abstime < 1n + Twrite_dur) ?
                    ((row1_value_right >> 8) & 1 ? v_high : v_low) : v_low, 0, trise);
	V(in1[9]) <+ transition(($abstime >= 1n + T_dur && $abstime < 1n + Twrite_dur) ?
                    ((row1_value_left >> 9) & 1 ? v_high : v_low) : v_low, 0, trise);
	V(in2[9]) <+ transition(($abstime >= 1n + T_dur && $abstime < 1n + Twrite_dur) ?
                    ((row1_value_right >> 9) & 1 ? v_high : v_low) : v_low, 0, trise);
	V(in1[10]) <+ transition(($abstime >= 1n + T_dur && $abstime < 1n + Twrite_dur) ?
                    ((row1_value_left >> 10) & 1 ? v_high : v_low) : v_low, 0, trise);
	V(in2[10]) <+ transition(($abstime >= 1n + T_dur && $abstime < 1n + Twrite_dur) ?
                    ((row1_value_right >> 10) & 1 ? v_high : v_low) : v_low, 0, trise);
	V(in1[11]) <+ transition(($abstime >= 1n + T_dur && $abstime < 1n + Twrite_dur) ?
                    ((row1_value_left >> 11) & 1 ? v_high : v_low) : v_low, 0, trise);
	V(in2[11]) <+ transition(($abstime >= 1n + T_dur && $abstime < 1n + Twrite_dur) ?
                    ((row1_value_right >> 11) & 1 ? v_high : v_low) : v_low, 0, trise);
	V(in1[12]) <+ transition(($abstime >= 1n + T_dur && $abstime < 1n + Twrite_dur) ?
                    ((row1_value_left >> 12) & 1 ? v_high : v_low) : v_low, 0, trise);
	V(in2[12]) <+ transition(($abstime >= 1n + T_dur && $abstime < 1n + Twrite_dur) ?
                    ((row1_value_right >> 12) & 1 ? v_high : v_low) : v_low, 0, trise);
	V(in1[13]) <+ transition(($abstime >= 1n + T_dur && $abstime < 1n + Twrite_dur) ?
                    ((row1_value_left >> 13) & 1 ? v_high : v_low) : v_low, 0, trise);
	V(in2[13]) <+ transition(($abstime >= 1n + T_dur && $abstime < 1n + Twrite_dur) ?
                    ((row1_value_right >> 13) & 1 ? v_high : v_low) : v_low, 0, trise);
	V(in1[14]) <+ transition(($abstime >= 1n + T_dur && $abstime < 1n + Twrite_dur) ?
                    ((row1_value_left >> 14) & 1 ? v_high : v_low) : v_low, 0, trise);
	V(in2[14]) <+ transition(($abstime >= 1n + T_dur && $abstime < 1n + Twrite_dur) ?
                    ((row1_value_right >> 14) & 1 ? v_high : v_low) : v_low, 0, trise);
	V(in1[15]) <+ transition(($abstime >= 1n + T_dur && $abstime < 1n + Twrite_dur) ?
                    ((row1_value_left >> 15) & 1 ? v_high : v_low) : v_low, 0, trise);
	V(in2[15]) <+ transition(($abstime >= 1n + T_dur && $abstime < 1n + Twrite_dur) ?
                    ((row1_value_right >> 15) & 1 ? v_high : v_low) : v_low, 0, trise);
	V(in1[16]) <+ transition(($abstime >= 1n + T_dur && $abstime < 1n + Twrite_dur) ?
                    ((row1_value_left >> 16) & 1 ? v_high : v_low) : v_low, 0, trise);
	V(in2[16]) <+ transition(($abstime >= 1n + T_dur && $abstime < 1n + Twrite_dur) ?
                    ((row1_value_right >> 16) & 1 ? v_high : v_low) : v_low, 0, trise);
	V(in1[17]) <+ transition(($abstime >= 1n + T_dur && $abstime < 1n + Twrite_dur) ?
                    ((row1_value_left >> 17) & 1 ? v_high : v_low) : v_low, 0, trise);
	V(in2[17]) <+ transition(($abstime >= 1n + T_dur && $abstime < 1n + Twrite_dur) ?
                    ((row1_value_right >> 17) & 1 ? v_high : v_low) : v_low, 0, trise);
	V(in1[18]) <+ transition(($abstime >= 1n + T_dur && $abstime < 1n + Twrite_dur) ?
                    ((row1_value_left >> 18) & 1 ? v_high : v_low) : v_low, 0, trise);
	V(in2[18]) <+ transition(($abstime >= 1n + T_dur && $abstime < 1n + Twrite_dur) ?
                    ((row1_value_right >> 18) & 1 ? v_high : v_low) : v_low, 0, trise);
	V(in1[19]) <+ transition(($abstime >= 1n + T_dur && $abstime < 1n + Twrite_dur) ?
                    ((row1_value_left >> 19) & 1 ? v_high : v_low) : v_low, 0, trise);
	V(in2[19]) <+ transition(($abstime >= 1n + T_dur && $abstime < 1n + Twrite_dur) ?
                    ((row1_value_right >> 19) & 1 ? v_high : v_low) : v_low, 0, trise);
	V(in1[20]) <+ transition(($abstime >= 1n + T_dur && $abstime < 1n + Twrite_dur) ?
                    ((row1_value_left >> 20) & 1 ? v_high : v_low) : v_low, 0, trise);
	V(in2[20]) <+ transition(($abstime >= 1n + T_dur && $abstime < 1n + Twrite_dur) ?
                    ((row1_value_right >> 20) & 1 ? v_high : v_low) : v_low, 0, trise);
	V(in1[21]) <+ transition(($abstime >= 1n + T_dur && $abstime < 1n + Twrite_dur) ?
                    ((row1_value_left >> 21) & 1 ? v_high : v_low) : v_low, 0, trise);
	V(in2[21]) <+ transition(($abstime >= 1n + T_dur && $abstime < 1n + Twrite_dur) ?
                    ((row1_value_right >> 21) & 1 ? v_high : v_low) : v_low, 0, trise);
	V(in1[22]) <+ transition(($abstime >= 1n + T_dur && $abstime < 1n + Twrite_dur) ?
                    ((row1_value_left >> 22) & 1 ? v_high : v_low) : v_low, 0, trise);
	V(in2[22]) <+ transition(($abstime >= 1n + T_dur && $abstime < 1n + Twrite_dur) ?
                    ((row1_value_right >> 22) & 1 ? v_high : v_low) : v_low, 0, trise);
	V(in1[23]) <+ transition(($abstime >= 1n + T_dur && $abstime < 1n + Twrite_dur) ?
                    ((row1_value_left >> 23) & 1 ? v_high : v_low) : v_low, 0, trise);
	V(in2[23]) <+ transition(($abstime >= 1n + T_dur && $abstime < 1n + Twrite_dur) ?
                    ((row1_value_right >> 23) & 1 ? v_high : v_low) : v_low, 0, trise);
	V(in1[24]) <+ transition(($abstime >= 1n + T_dur && $abstime < 1n + Twrite_dur) ?
                    ((row1_value_left >> 24) & 1 ? v_high : v_low) : v_low, 0, trise);
	V(in2[24]) <+ transition(($abstime >= 1n + T_dur && $abstime < 1n + Twrite_dur) ?
                    ((row1_value_right >> 24) & 1 ? v_high : v_low) : v_low, 0, trise);
	V(in1[25]) <+ transition(($abstime >= 1n + T_dur && $abstime < 1n + Twrite_dur) ?
                    ((row1_value_left >> 25) & 1 ? v_high : v_low) : v_low, 0, trise);
	V(in2[25]) <+ transition(($abstime >= 1n + T_dur && $abstime < 1n + Twrite_dur) ?
                    ((row1_value_right >> 25) & 1 ? v_high : v_low) : v_low, 0, trise);
	V(in1[26]) <+ transition(($abstime >= 1n + T_dur && $abstime < 1n + Twrite_dur) ?
                    ((row1_value_left >> 26) & 1 ? v_high : v_low) : v_low, 0, trise);
	V(in2[26]) <+ transition(($abstime >= 1n + T_dur && $abstime < 1n + Twrite_dur) ?
                    ((row1_value_right >> 26) & 1 ? v_high : v_low) : v_low, 0, trise);
	V(in1[27]) <+ transition(($abstime >= 1n + T_dur && $abstime < 1n + Twrite_dur) ?
                    ((row1_value_left >> 27) & 1 ? v_high : v_low) : v_low, 0, trise);
	V(in2[27]) <+ transition(($abstime >= 1n + T_dur && $abstime < 1n + Twrite_dur) ?
                    ((row1_value_right >> 27) & 1 ? v_high : v_low) : v_low, 0, trise);
	V(in1[28]) <+ transition(($abstime >= 1n + T_dur && $abstime < 1n + Twrite_dur) ?
                    ((row1_value_left >> 28) & 1 ? v_high : v_low) : v_low, 0, trise);
	V(in2[28]) <+ transition(($abstime >= 1n + T_dur && $abstime < 1n + Twrite_dur) ?
                    ((row1_value_right >> 28) & 1 ? v_high : v_low) : v_low, 0, trise);
	V(in1[29]) <+ transition(($abstime >= 1n + T_dur && $abstime < 1n + Twrite_dur) ?
                    ((row1_value_left >> 29) & 1 ? v_high : v_low) : v_low, 0, trise);
	V(in2[29]) <+ transition(($abstime >= 1n + T_dur && $abstime < 1n + Twrite_dur) ?
                    ((row1_value_right >> 29) & 1 ? v_high : v_low) : v_low, 0, trise);
	V(in1[30]) <+ transition(($abstime >= 1n + T_dur && $abstime < 1n + Twrite_dur) ?
                    ((row1_value_left >> 30) & 1 ? v_high : v_low) : v_low, 0, trise);
	V(in2[30]) <+ transition(($abstime >= 1n + T_dur && $abstime < 1n + Twrite_dur) ?
                    ((row1_value_right >> 30) & 1 ? v_high : v_low) : v_low, 0, trise);
	V(in1[31]) <+ transition(($abstime >= 1n + T_dur && $abstime < 1n + Twrite_dur) ?
                    ((row1_value_left >> 31) & 1 ? v_high : v_low) : v_low, 0, trise);
	V(in2[31]) <+ transition(($abstime >= 1n + T_dur && $abstime < 1n + Twrite_dur) ?
                    ((row1_value_right >> 31) & 1 ? v_high : v_low) : v_low, 0, trise);

    V(write) <+ transition(($abstime >= 2n + T_dur && $abstime < 2n + Twrite_dur) ? v_high : v_low, 0, trise);
    V(WL[2]) <+ transition(($abstime >= 2n + T_dur && $abstime < 2n + TWL_dur) ? v_high : v_low, 0, trise);
	V(in1[0]) <+ transition(($abstime >= 2n + T_dur && $abstime < 2n + Twrite_dur) ?
                    ((row2_value_left >> 0) & 1 ? v_high : v_low) : v_low, 0, trise);
	V(in2[0]) <+ transition(($abstime >= 2n + T_dur && $abstime < 2n + Twrite_dur) ?
                    ((row2_value_right >> 0) & 1 ? v_high : v_low) : v_low, 0, trise);
	V(in1[1]) <+ transition(($abstime >= 2n + T_dur && $abstime < 2n + Twrite_dur) ?
                    ((row2_value_left >> 1) & 1 ? v_high : v_low) : v_low, 0, trise);
	V(in2[1]) <+ transition(($abstime >= 2n + T_dur && $abstime < 2n + Twrite_dur) ?
                    ((row2_value_right >> 1) & 1 ? v_high : v_low) : v_low, 0, trise);
	V(in1[2]) <+ transition(($abstime >= 2n + T_dur && $abstime < 2n + Twrite_dur) ?
                    ((row2_value_left >> 2) & 1 ? v_high : v_low) : v_low, 0, trise);
	V(in2[2]) <+ transition(($abstime >= 2n + T_dur && $abstime < 2n + Twrite_dur) ?
                    ((row2_value_right >> 2) & 1 ? v_high : v_low) : v_low, 0, trise);
	V(in1[3]) <+ transition(($abstime >= 2n + T_dur && $abstime < 2n + Twrite_dur) ?
                    ((row2_value_left >> 3) & 1 ? v_high : v_low) : v_low, 0, trise);
	V(in2[3]) <+ transition(($abstime >= 2n + T_dur && $abstime < 2n + Twrite_dur) ?
                    ((row2_value_right >> 3) & 1 ? v_high : v_low) : v_low, 0, trise);
	V(in1[4]) <+ transition(($abstime >= 2n + T_dur && $abstime < 2n + Twrite_dur) ?
                    ((row2_value_left >> 4) & 1 ? v_high : v_low) : v_low, 0, trise);
	V(in2[4]) <+ transition(($abstime >= 2n + T_dur && $abstime < 2n + Twrite_dur) ?
                    ((row2_value_right >> 4) & 1 ? v_high : v_low) : v_low, 0, trise);
	V(in1[5]) <+ transition(($abstime >= 2n + T_dur && $abstime < 2n + Twrite_dur) ?
                    ((row2_value_left >> 5) & 1 ? v_high : v_low) : v_low, 0, trise);
	V(in2[5]) <+ transition(($abstime >= 2n + T_dur && $abstime < 2n + Twrite_dur) ?
                    ((row2_value_right >> 5) & 1 ? v_high : v_low) : v_low, 0, trise);
	V(in1[6]) <+ transition(($abstime >= 2n + T_dur && $abstime < 2n + Twrite_dur) ?
                    ((row2_value_left >> 6) & 1 ? v_high : v_low) : v_low, 0, trise);
	V(in2[6]) <+ transition(($abstime >= 2n + T_dur && $abstime < 2n + Twrite_dur) ?
                    ((row2_value_right >> 6) & 1 ? v_high : v_low) : v_low, 0, trise);
	V(in1[7]) <+ transition(($abstime >= 2n + T_dur && $abstime < 2n + Twrite_dur) ?
                    ((row2_value_left >> 7) & 1 ? v_high : v_low) : v_low, 0, trise);
	V(in2[7]) <+ transition(($abstime >= 2n + T_dur && $abstime < 2n + Twrite_dur) ?
                    ((row2_value_right >> 7) & 1 ? v_high : v_low) : v_low, 0, trise);
	V(in1[8]) <+ transition(($abstime >= 2n + T_dur && $abstime < 2n + Twrite_dur) ?
                    ((row2_value_left >> 8) & 1 ? v_high : v_low) : v_low, 0, trise);
	V(in2[8]) <+ transition(($abstime >= 2n + T_dur && $abstime < 2n + Twrite_dur) ?
                    ((row2_value_right >> 8) & 1 ? v_high : v_low) : v_low, 0, trise);
	V(in1[9]) <+ transition(($abstime >= 2n + T_dur && $abstime < 2n + Twrite_dur) ?
                    ((row2_value_left >> 9) & 1 ? v_high : v_low) : v_low, 0, trise);
	V(in2[9]) <+ transition(($abstime >= 2n + T_dur && $abstime < 2n + Twrite_dur) ?
                    ((row2_value_right >> 9) & 1 ? v_high : v_low) : v_low, 0, trise);
	V(in1[10]) <+ transition(($abstime >= 2n + T_dur && $abstime < 2n + Twrite_dur) ?
                    ((row2_value_left >> 10) & 1 ? v_high : v_low) : v_low, 0, trise);
	V(in2[10]) <+ transition(($abstime >= 2n + T_dur && $abstime < 2n + Twrite_dur) ?
                    ((row2_value_right >> 10) & 1 ? v_high : v_low) : v_low, 0, trise);
	V(in1[11]) <+ transition(($abstime >= 2n + T_dur && $abstime < 2n + Twrite_dur) ?
                    ((row2_value_left >> 11) & 1 ? v_high : v_low) : v_low, 0, trise);
	V(in2[11]) <+ transition(($abstime >= 2n + T_dur && $abstime < 2n + Twrite_dur) ?
                    ((row2_value_right >> 11) & 1 ? v_high : v_low) : v_low, 0, trise);
	V(in1[12]) <+ transition(($abstime >= 2n + T_dur && $abstime < 2n + Twrite_dur) ?
                    ((row2_value_left >> 12) & 1 ? v_high : v_low) : v_low, 0, trise);
	V(in2[12]) <+ transition(($abstime >= 2n + T_dur && $abstime < 2n + Twrite_dur) ?
                    ((row2_value_right >> 12) & 1 ? v_high : v_low) : v_low, 0, trise);
	V(in1[13]) <+ transition(($abstime >= 2n + T_dur && $abstime < 2n + Twrite_dur) ?
                    ((row2_value_left >> 13) & 1 ? v_high : v_low) : v_low, 0, trise);
	V(in2[13]) <+ transition(($abstime >= 2n + T_dur && $abstime < 2n + Twrite_dur) ?
                    ((row2_value_right >> 13) & 1 ? v_high : v_low) : v_low, 0, trise);
	V(in1[14]) <+ transition(($abstime >= 2n + T_dur && $abstime < 2n + Twrite_dur) ?
                    ((row2_value_left >> 14) & 1 ? v_high : v_low) : v_low, 0, trise);
	V(in2[14]) <+ transition(($abstime >= 2n + T_dur && $abstime < 2n + Twrite_dur) ?
                    ((row2_value_right >> 14) & 1 ? v_high : v_low) : v_low, 0, trise);
	V(in1[15]) <+ transition(($abstime >= 2n + T_dur && $abstime < 2n + Twrite_dur) ?
                    ((row2_value_left >> 15) & 1 ? v_high : v_low) : v_low, 0, trise);
	V(in2[15]) <+ transition(($abstime >= 2n + T_dur && $abstime < 2n + Twrite_dur) ?
                    ((row2_value_right >> 15) & 1 ? v_high : v_low) : v_low, 0, trise);
	V(in1[16]) <+ transition(($abstime >= 2n + T_dur && $abstime < 2n + Twrite_dur) ?
                    ((row2_value_left >> 16) & 1 ? v_high : v_low) : v_low, 0, trise);
	V(in2[16]) <+ transition(($abstime >= 2n + T_dur && $abstime < 2n + Twrite_dur) ?
                    ((row2_value_right >> 16) & 1 ? v_high : v_low) : v_low, 0, trise);
	V(in1[17]) <+ transition(($abstime >= 2n + T_dur && $abstime < 2n + Twrite_dur) ?
                    ((row2_value_left >> 17) & 1 ? v_high : v_low) : v_low, 0, trise);
	V(in2[17]) <+ transition(($abstime >= 2n + T_dur && $abstime < 2n + Twrite_dur) ?
                    ((row2_value_right >> 17) & 1 ? v_high : v_low) : v_low, 0, trise);
	V(in1[18]) <+ transition(($abstime >= 2n + T_dur && $abstime < 2n + Twrite_dur) ?
                    ((row2_value_left >> 18) & 1 ? v_high : v_low) : v_low, 0, trise);
	V(in2[18]) <+ transition(($abstime >= 2n + T_dur && $abstime < 2n + Twrite_dur) ?
                    ((row2_value_right >> 18) & 1 ? v_high : v_low) : v_low, 0, trise);
	V(in1[19]) <+ transition(($abstime >= 2n + T_dur && $abstime < 2n + Twrite_dur) ?
                    ((row2_value_left >> 19) & 1 ? v_high : v_low) : v_low, 0, trise);
	V(in2[19]) <+ transition(($abstime >= 2n + T_dur && $abstime < 2n + Twrite_dur) ?
                    ((row2_value_right >> 19) & 1 ? v_high : v_low) : v_low, 0, trise);
	V(in1[20]) <+ transition(($abstime >= 2n + T_dur && $abstime < 2n + Twrite_dur) ?
                    ((row2_value_left >> 20) & 1 ? v_high : v_low) : v_low, 0, trise);
	V(in2[20]) <+ transition(($abstime >= 2n + T_dur && $abstime < 2n + Twrite_dur) ?
                    ((row2_value_right >> 20) & 1 ? v_high : v_low) : v_low, 0, trise);
	V(in1[21]) <+ transition(($abstime >= 2n + T_dur && $abstime < 2n + Twrite_dur) ?
                    ((row2_value_left >> 21) & 1 ? v_high : v_low) : v_low, 0, trise);
	V(in2[21]) <+ transition(($abstime >= 2n + T_dur && $abstime < 2n + Twrite_dur) ?
                    ((row2_value_right >> 21) & 1 ? v_high : v_low) : v_low, 0, trise);
	V(in1[22]) <+ transition(($abstime >= 2n + T_dur && $abstime < 2n + Twrite_dur) ?
                    ((row2_value_left >> 22) & 1 ? v_high : v_low) : v_low, 0, trise);
	V(in2[22]) <+ transition(($abstime >= 2n + T_dur && $abstime < 2n + Twrite_dur) ?
                    ((row2_value_right >> 22) & 1 ? v_high : v_low) : v_low, 0, trise);
	V(in1[23]) <+ transition(($abstime >= 2n + T_dur && $abstime < 2n + Twrite_dur) ?
                    ((row2_value_left >> 23) & 1 ? v_high : v_low) : v_low, 0, trise);
	V(in2[23]) <+ transition(($abstime >= 2n + T_dur && $abstime < 2n + Twrite_dur) ?
                    ((row2_value_right >> 23) & 1 ? v_high : v_low) : v_low, 0, trise);
	V(in1[24]) <+ transition(($abstime >= 2n + T_dur && $abstime < 2n + Twrite_dur) ?
                    ((row2_value_left >> 24) & 1 ? v_high : v_low) : v_low, 0, trise);
	V(in2[24]) <+ transition(($abstime >= 2n + T_dur && $abstime < 2n + Twrite_dur) ?
                    ((row2_value_right >> 24) & 1 ? v_high : v_low) : v_low, 0, trise);
	V(in1[25]) <+ transition(($abstime >= 2n + T_dur && $abstime < 2n + Twrite_dur) ?
                    ((row2_value_left >> 25) & 1 ? v_high : v_low) : v_low, 0, trise);
	V(in2[25]) <+ transition(($abstime >= 2n + T_dur && $abstime < 2n + Twrite_dur) ?
                    ((row2_value_right >> 25) & 1 ? v_high : v_low) : v_low, 0, trise);
	V(in1[26]) <+ transition(($abstime >= 2n + T_dur && $abstime < 2n + Twrite_dur) ?
                    ((row2_value_left >> 26) & 1 ? v_high : v_low) : v_low, 0, trise);
	V(in2[26]) <+ transition(($abstime >= 2n + T_dur && $abstime < 2n + Twrite_dur) ?
                    ((row2_value_right >> 26) & 1 ? v_high : v_low) : v_low, 0, trise);
	V(in1[27]) <+ transition(($abstime >= 2n + T_dur && $abstime < 2n + Twrite_dur) ?
                    ((row2_value_left >> 27) & 1 ? v_high : v_low) : v_low, 0, trise);
	V(in2[27]) <+ transition(($abstime >= 2n + T_dur && $abstime < 2n + Twrite_dur) ?
                    ((row2_value_right >> 27) & 1 ? v_high : v_low) : v_low, 0, trise);
	V(in1[28]) <+ transition(($abstime >= 2n + T_dur && $abstime < 2n + Twrite_dur) ?
                    ((row2_value_left >> 28) & 1 ? v_high : v_low) : v_low, 0, trise);
	V(in2[28]) <+ transition(($abstime >= 2n + T_dur && $abstime < 2n + Twrite_dur) ?
                    ((row2_value_right >> 28) & 1 ? v_high : v_low) : v_low, 0, trise);
	V(in1[29]) <+ transition(($abstime >= 2n + T_dur && $abstime < 2n + Twrite_dur) ?
                    ((row2_value_left >> 29) & 1 ? v_high : v_low) : v_low, 0, trise);
	V(in2[29]) <+ transition(($abstime >= 2n + T_dur && $abstime < 2n + Twrite_dur) ?
                    ((row2_value_right >> 29) & 1 ? v_high : v_low) : v_low, 0, trise);
	V(in1[30]) <+ transition(($abstime >= 2n + T_dur && $abstime < 2n + Twrite_dur) ?
                    ((row2_value_left >> 30) & 1 ? v_high : v_low) : v_low, 0, trise);
	V(in2[30]) <+ transition(($abstime >= 2n + T_dur && $abstime < 2n + Twrite_dur) ?
                    ((row2_value_right >> 30) & 1 ? v_high : v_low) : v_low, 0, trise);
	V(in1[31]) <+ transition(($abstime >= 2n + T_dur && $abstime < 2n + Twrite_dur) ?
                    ((row2_value_left >> 31) & 1 ? v_high : v_low) : v_low, 0, trise);
	V(in2[31]) <+ transition(($abstime >= 2n + T_dur && $abstime < 2n + Twrite_dur) ?
                    ((row2_value_right >> 31) & 1 ? v_high : v_low) : v_low, 0, trise);

    V(write) <+ transition(($abstime >= 3n + T_dur && $abstime < 3n + Twrite_dur) ? v_high : v_low, 0, trise);
    V(WL[3]) <+ transition(($abstime >= 3n + T_dur && $abstime < 3n + TWL_dur) ? v_high : v_low, 0, trise);
	V(in1[0]) <+ transition(($abstime >= 3n + T_dur && $abstime < 3n + Twrite_dur) ?
                    ((row3_value_left >> 0) & 1 ? v_high : v_low) : v_low, 0, trise);
	V(in2[0]) <+ transition(($abstime >= 3n + T_dur && $abstime < 3n + Twrite_dur) ?
                    ((row3_value_right >> 0) & 1 ? v_high : v_low) : v_low, 0, trise);
	V(in1[1]) <+ transition(($abstime >= 3n + T_dur && $abstime < 3n + Twrite_dur) ?
                    ((row3_value_left >> 1) & 1 ? v_high : v_low) : v_low, 0, trise);
	V(in2[1]) <+ transition(($abstime >= 3n + T_dur && $abstime < 3n + Twrite_dur) ?
                    ((row3_value_right >> 1) & 1 ? v_high : v_low) : v_low, 0, trise);
	V(in1[2]) <+ transition(($abstime >= 3n + T_dur && $abstime < 3n + Twrite_dur) ?
                    ((row3_value_left >> 2) & 1 ? v_high : v_low) : v_low, 0, trise);
	V(in2[2]) <+ transition(($abstime >= 3n + T_dur && $abstime < 3n + Twrite_dur) ?
                    ((row3_value_right >> 2) & 1 ? v_high : v_low) : v_low, 0, trise);
	V(in1[3]) <+ transition(($abstime >= 3n + T_dur && $abstime < 3n + Twrite_dur) ?
                    ((row3_value_left >> 3) & 1 ? v_high : v_low) : v_low, 0, trise);
	V(in2[3]) <+ transition(($abstime >= 3n + T_dur && $abstime < 3n + Twrite_dur) ?
                    ((row3_value_right >> 3) & 1 ? v_high : v_low) : v_low, 0, trise);
	V(in1[4]) <+ transition(($abstime >= 3n + T_dur && $abstime < 3n + Twrite_dur) ?
                    ((row3_value_left >> 4) & 1 ? v_high : v_low) : v_low, 0, trise);
	V(in2[4]) <+ transition(($abstime >= 3n + T_dur && $abstime < 3n + Twrite_dur) ?
                    ((row3_value_right >> 4) & 1 ? v_high : v_low) : v_low, 0, trise);
	V(in1[5]) <+ transition(($abstime >= 3n + T_dur && $abstime < 3n + Twrite_dur) ?
                    ((row3_value_left >> 5) & 1 ? v_high : v_low) : v_low, 0, trise);
	V(in2[5]) <+ transition(($abstime >= 3n + T_dur && $abstime < 3n + Twrite_dur) ?
                    ((row3_value_right >> 5) & 1 ? v_high : v_low) : v_low, 0, trise);
	V(in1[6]) <+ transition(($abstime >= 3n + T_dur && $abstime < 3n + Twrite_dur) ?
                    ((row3_value_left >> 6) & 1 ? v_high : v_low) : v_low, 0, trise);
	V(in2[6]) <+ transition(($abstime >= 3n + T_dur && $abstime < 3n + Twrite_dur) ?
                    ((row3_value_right >> 6) & 1 ? v_high : v_low) : v_low, 0, trise);
	V(in1[7]) <+ transition(($abstime >= 3n + T_dur && $abstime < 3n + Twrite_dur) ?
                    ((row3_value_left >> 7) & 1 ? v_high : v_low) : v_low, 0, trise);
	V(in2[7]) <+ transition(($abstime >= 3n + T_dur && $abstime < 3n + Twrite_dur) ?
                    ((row3_value_right >> 7) & 1 ? v_high : v_low) : v_low, 0, trise);
	V(in1[8]) <+ transition(($abstime >= 3n + T_dur && $abstime < 3n + Twrite_dur) ?
                    ((row3_value_left >> 8) & 1 ? v_high : v_low) : v_low, 0, trise);
	V(in2[8]) <+ transition(($abstime >= 3n + T_dur && $abstime < 3n + Twrite_dur) ?
                    ((row3_value_right >> 8) & 1 ? v_high : v_low) : v_low, 0, trise);
	V(in1[9]) <+ transition(($abstime >= 3n + T_dur && $abstime < 3n + Twrite_dur) ?
                    ((row3_value_left >> 9) & 1 ? v_high : v_low) : v_low, 0, trise);
	V(in2[9]) <+ transition(($abstime >= 3n + T_dur && $abstime < 3n + Twrite_dur) ?
                    ((row3_value_right >> 9) & 1 ? v_high : v_low) : v_low, 0, trise);
	V(in1[10]) <+ transition(($abstime >= 3n + T_dur && $abstime < 3n + Twrite_dur) ?
                    ((row3_value_left >> 10) & 1 ? v_high : v_low) : v_low, 0, trise);
	V(in2[10]) <+ transition(($abstime >= 3n + T_dur && $abstime < 3n + Twrite_dur) ?
                    ((row3_value_right >> 10) & 1 ? v_high : v_low) : v_low, 0, trise);
	V(in1[11]) <+ transition(($abstime >= 3n + T_dur && $abstime < 3n + Twrite_dur) ?
                    ((row3_value_left >> 11) & 1 ? v_high : v_low) : v_low, 0, trise);
	V(in2[11]) <+ transition(($abstime >= 3n + T_dur && $abstime < 3n + Twrite_dur) ?
                    ((row3_value_right >> 11) & 1 ? v_high : v_low) : v_low, 0, trise);
	V(in1[12]) <+ transition(($abstime >= 3n + T_dur && $abstime < 3n + Twrite_dur) ?
                    ((row3_value_left >> 12) & 1 ? v_high : v_low) : v_low, 0, trise);
	V(in2[12]) <+ transition(($abstime >= 3n + T_dur && $abstime < 3n + Twrite_dur) ?
                    ((row3_value_right >> 12) & 1 ? v_high : v_low) : v_low, 0, trise);
	V(in1[13]) <+ transition(($abstime >= 3n + T_dur && $abstime < 3n + Twrite_dur) ?
                    ((row3_value_left >> 13) & 1 ? v_high : v_low) : v_low, 0, trise);
	V(in2[13]) <+ transition(($abstime >= 3n + T_dur && $abstime < 3n + Twrite_dur) ?
                    ((row3_value_right >> 13) & 1 ? v_high : v_low) : v_low, 0, trise);
	V(in1[14]) <+ transition(($abstime >= 3n + T_dur && $abstime < 3n + Twrite_dur) ?
                    ((row3_value_left >> 14) & 1 ? v_high : v_low) : v_low, 0, trise);
	V(in2[14]) <+ transition(($abstime >= 3n + T_dur && $abstime < 3n + Twrite_dur) ?
                    ((row3_value_right >> 14) & 1 ? v_high : v_low) : v_low, 0, trise);
	V(in1[15]) <+ transition(($abstime >= 3n + T_dur && $abstime < 3n + Twrite_dur) ?
                    ((row3_value_left >> 15) & 1 ? v_high : v_low) : v_low, 0, trise);
	V(in2[15]) <+ transition(($abstime >= 3n + T_dur && $abstime < 3n + Twrite_dur) ?
                    ((row3_value_right >> 15) & 1 ? v_high : v_low) : v_low, 0, trise);
	V(in1[16]) <+ transition(($abstime >= 3n + T_dur && $abstime < 3n + Twrite_dur) ?
                    ((row3_value_left >> 16) & 1 ? v_high : v_low) : v_low, 0, trise);
	V(in2[16]) <+ transition(($abstime >= 3n + T_dur && $abstime < 3n + Twrite_dur) ?
                    ((row3_value_right >> 16) & 1 ? v_high : v_low) : v_low, 0, trise);
	V(in1[17]) <+ transition(($abstime >= 3n + T_dur && $abstime < 3n + Twrite_dur) ?
                    ((row3_value_left >> 17) & 1 ? v_high : v_low) : v_low, 0, trise);
	V(in2[17]) <+ transition(($abstime >= 3n + T_dur && $abstime < 3n + Twrite_dur) ?
                    ((row3_value_right >> 17) & 1 ? v_high : v_low) : v_low, 0, trise);
	V(in1[18]) <+ transition(($abstime >= 3n + T_dur && $abstime < 3n + Twrite_dur) ?
                    ((row3_value_left >> 18) & 1 ? v_high : v_low) : v_low, 0, trise);
	V(in2[18]) <+ transition(($abstime >= 3n + T_dur && $abstime < 3n + Twrite_dur) ?
                    ((row3_value_right >> 18) & 1 ? v_high : v_low) : v_low, 0, trise);
	V(in1[19]) <+ transition(($abstime >= 3n + T_dur && $abstime < 3n + Twrite_dur) ?
                    ((row3_value_left >> 19) & 1 ? v_high : v_low) : v_low, 0, trise);
	V(in2[19]) <+ transition(($abstime >= 3n + T_dur && $abstime < 3n + Twrite_dur) ?
                    ((row3_value_right >> 19) & 1 ? v_high : v_low) : v_low, 0, trise);
	V(in1[20]) <+ transition(($abstime >= 3n + T_dur && $abstime < 3n + Twrite_dur) ?
                    ((row3_value_left >> 20) & 1 ? v_high : v_low) : v_low, 0, trise);
	V(in2[20]) <+ transition(($abstime >= 3n + T_dur && $abstime < 3n + Twrite_dur) ?
                    ((row3_value_right >> 20) & 1 ? v_high : v_low) : v_low, 0, trise);
	V(in1[21]) <+ transition(($abstime >= 3n + T_dur && $abstime < 3n + Twrite_dur) ?
                    ((row3_value_left >> 21) & 1 ? v_high : v_low) : v_low, 0, trise);
	V(in2[21]) <+ transition(($abstime >= 3n + T_dur && $abstime < 3n + Twrite_dur) ?
                    ((row3_value_right >> 21) & 1 ? v_high : v_low) : v_low, 0, trise);
	V(in1[22]) <+ transition(($abstime >= 3n + T_dur && $abstime < 3n + Twrite_dur) ?
                    ((row3_value_left >> 22) & 1 ? v_high : v_low) : v_low, 0, trise);
	V(in2[22]) <+ transition(($abstime >= 3n + T_dur && $abstime < 3n + Twrite_dur) ?
                    ((row3_value_right >> 22) & 1 ? v_high : v_low) : v_low, 0, trise);
	V(in1[23]) <+ transition(($abstime >= 3n + T_dur && $abstime < 3n + Twrite_dur) ?
                    ((row3_value_left >> 23) & 1 ? v_high : v_low) : v_low, 0, trise);
	V(in2[23]) <+ transition(($abstime >= 3n + T_dur && $abstime < 3n + Twrite_dur) ?
                    ((row3_value_right >> 23) & 1 ? v_high : v_low) : v_low, 0, trise);
	V(in1[24]) <+ transition(($abstime >= 3n + T_dur && $abstime < 3n + Twrite_dur) ?
                    ((row3_value_left >> 24) & 1 ? v_high : v_low) : v_low, 0, trise);
	V(in2[24]) <+ transition(($abstime >= 3n + T_dur && $abstime < 3n + Twrite_dur) ?
                    ((row3_value_right >> 24) & 1 ? v_high : v_low) : v_low, 0, trise);
	V(in1[25]) <+ transition(($abstime >= 3n + T_dur && $abstime < 3n + Twrite_dur) ?
                    ((row3_value_left >> 25) & 1 ? v_high : v_low) : v_low, 0, trise);
	V(in2[25]) <+ transition(($abstime >= 3n + T_dur && $abstime < 3n + Twrite_dur) ?
                    ((row3_value_right >> 25) & 1 ? v_high : v_low) : v_low, 0, trise);
	V(in1[26]) <+ transition(($abstime >= 3n + T_dur && $abstime < 3n + Twrite_dur) ?
                    ((row3_value_left >> 26) & 1 ? v_high : v_low) : v_low, 0, trise);
	V(in2[26]) <+ transition(($abstime >= 3n + T_dur && $abstime < 3n + Twrite_dur) ?
                    ((row3_value_right >> 26) & 1 ? v_high : v_low) : v_low, 0, trise);
	V(in1[27]) <+ transition(($abstime >= 3n + T_dur && $abstime < 3n + Twrite_dur) ?
                    ((row3_value_left >> 27) & 1 ? v_high : v_low) : v_low, 0, trise);
	V(in2[27]) <+ transition(($abstime >= 3n + T_dur && $abstime < 3n + Twrite_dur) ?
                    ((row3_value_right >> 27) & 1 ? v_high : v_low) : v_low, 0, trise);
	V(in1[28]) <+ transition(($abstime >= 3n + T_dur && $abstime < 3n + Twrite_dur) ?
                    ((row3_value_left >> 28) & 1 ? v_high : v_low) : v_low, 0, trise);
	V(in2[28]) <+ transition(($abstime >= 3n + T_dur && $abstime < 3n + Twrite_dur) ?
                    ((row3_value_right >> 28) & 1 ? v_high : v_low) : v_low, 0, trise);
	V(in1[29]) <+ transition(($abstime >= 3n + T_dur && $abstime < 3n + Twrite_dur) ?
                    ((row3_value_left >> 29) & 1 ? v_high : v_low) : v_low, 0, trise);
	V(in2[29]) <+ transition(($abstime >= 3n + T_dur && $abstime < 3n + Twrite_dur) ?
                    ((row3_value_right >> 29) & 1 ? v_high : v_low) : v_low, 0, trise);
	V(in1[30]) <+ transition(($abstime >= 3n + T_dur && $abstime < 3n + Twrite_dur) ?
                    ((row3_value_left >> 30) & 1 ? v_high : v_low) : v_low, 0, trise);
	V(in2[30]) <+ transition(($abstime >= 3n + T_dur && $abstime < 3n + Twrite_dur) ?
                    ((row3_value_right >> 30) & 1 ? v_high : v_low) : v_low, 0, trise);
	V(in1[31]) <+ transition(($abstime >= 3n + T_dur && $abstime < 3n + Twrite_dur) ?
                    ((row3_value_left >> 31) & 1 ? v_high : v_low) : v_low, 0, trise);
	V(in2[31]) <+ transition(($abstime >= 3n + T_dur && $abstime < 3n + Twrite_dur) ?
                    ((row3_value_right >> 31) & 1 ? v_high : v_low) : v_low, 0, trise);

    V(write) <+ transition(($abstime >= 4n + T_dur && $abstime < 4n + Twrite_dur) ? v_high : v_low, 0, trise);
    V(WL[4]) <+ transition(($abstime >= 4n + T_dur && $abstime < 4n + TWL_dur) ? v_high : v_low, 0, trise);
	V(in1[0]) <+ transition(($abstime >= 4n + T_dur && $abstime < 4n + Twrite_dur) ?
                    ((row4_value_left >> 0) & 1 ? v_high : v_low) : v_low, 0, trise);
	V(in2[0]) <+ transition(($abstime >= 4n + T_dur && $abstime < 4n + Twrite_dur) ?
                    ((row4_value_right >> 0) & 1 ? v_high : v_low) : v_low, 0, trise);
	V(in1[1]) <+ transition(($abstime >= 4n + T_dur && $abstime < 4n + Twrite_dur) ?
                    ((row4_value_left >> 1) & 1 ? v_high : v_low) : v_low, 0, trise);
	V(in2[1]) <+ transition(($abstime >= 4n + T_dur && $abstime < 4n + Twrite_dur) ?
                    ((row4_value_right >> 1) & 1 ? v_high : v_low) : v_low, 0, trise);
	V(in1[2]) <+ transition(($abstime >= 4n + T_dur && $abstime < 4n + Twrite_dur) ?
                    ((row4_value_left >> 2) & 1 ? v_high : v_low) : v_low, 0, trise);
	V(in2[2]) <+ transition(($abstime >= 4n + T_dur && $abstime < 4n + Twrite_dur) ?
                    ((row4_value_right >> 2) & 1 ? v_high : v_low) : v_low, 0, trise);
	V(in1[3]) <+ transition(($abstime >= 4n + T_dur && $abstime < 4n + Twrite_dur) ?
                    ((row4_value_left >> 3) & 1 ? v_high : v_low) : v_low, 0, trise);
	V(in2[3]) <+ transition(($abstime >= 4n + T_dur && $abstime < 4n + Twrite_dur) ?
                    ((row4_value_right >> 3) & 1 ? v_high : v_low) : v_low, 0, trise);
	V(in1[4]) <+ transition(($abstime >= 4n + T_dur && $abstime < 4n + Twrite_dur) ?
                    ((row4_value_left >> 4) & 1 ? v_high : v_low) : v_low, 0, trise);
	V(in2[4]) <+ transition(($abstime >= 4n + T_dur && $abstime < 4n + Twrite_dur) ?
                    ((row4_value_right >> 4) & 1 ? v_high : v_low) : v_low, 0, trise);
	V(in1[5]) <+ transition(($abstime >= 4n + T_dur && $abstime < 4n + Twrite_dur) ?
                    ((row4_value_left >> 5) & 1 ? v_high : v_low) : v_low, 0, trise);
	V(in2[5]) <+ transition(($abstime >= 4n + T_dur && $abstime < 4n + Twrite_dur) ?
                    ((row4_value_right >> 5) & 1 ? v_high : v_low) : v_low, 0, trise);
	V(in1[6]) <+ transition(($abstime >= 4n + T_dur && $abstime < 4n + Twrite_dur) ?
                    ((row4_value_left >> 6) & 1 ? v_high : v_low) : v_low, 0, trise);
	V(in2[6]) <+ transition(($abstime >= 4n + T_dur && $abstime < 4n + Twrite_dur) ?
                    ((row4_value_right >> 6) & 1 ? v_high : v_low) : v_low, 0, trise);
	V(in1[7]) <+ transition(($abstime >= 4n + T_dur && $abstime < 4n + Twrite_dur) ?
                    ((row4_value_left >> 7) & 1 ? v_high : v_low) : v_low, 0, trise);
	V(in2[7]) <+ transition(($abstime >= 4n + T_dur && $abstime < 4n + Twrite_dur) ?
                    ((row4_value_right >> 7) & 1 ? v_high : v_low) : v_low, 0, trise);
	V(in1[8]) <+ transition(($abstime >= 4n + T_dur && $abstime < 4n + Twrite_dur) ?
                    ((row4_value_left >> 8) & 1 ? v_high : v_low) : v_low, 0, trise);
	V(in2[8]) <+ transition(($abstime >= 4n + T_dur && $abstime < 4n + Twrite_dur) ?
                    ((row4_value_right >> 8) & 1 ? v_high : v_low) : v_low, 0, trise);
	V(in1[9]) <+ transition(($abstime >= 4n + T_dur && $abstime < 4n + Twrite_dur) ?
                    ((row4_value_left >> 9) & 1 ? v_high : v_low) : v_low, 0, trise);
	V(in2[9]) <+ transition(($abstime >= 4n + T_dur && $abstime < 4n + Twrite_dur) ?
                    ((row4_value_right >> 9) & 1 ? v_high : v_low) : v_low, 0, trise);
	V(in1[10]) <+ transition(($abstime >= 4n + T_dur && $abstime < 4n + Twrite_dur) ?
                    ((row4_value_left >> 10) & 1 ? v_high : v_low) : v_low, 0, trise);
	V(in2[10]) <+ transition(($abstime >= 4n + T_dur && $abstime < 4n + Twrite_dur) ?
                    ((row4_value_right >> 10) & 1 ? v_high : v_low) : v_low, 0, trise);
	V(in1[11]) <+ transition(($abstime >= 4n + T_dur && $abstime < 4n + Twrite_dur) ?
                    ((row4_value_left >> 11) & 1 ? v_high : v_low) : v_low, 0, trise);
	V(in2[11]) <+ transition(($abstime >= 4n + T_dur && $abstime < 4n + Twrite_dur) ?
                    ((row4_value_right >> 11) & 1 ? v_high : v_low) : v_low, 0, trise);
	V(in1[12]) <+ transition(($abstime >= 4n + T_dur && $abstime < 4n + Twrite_dur) ?
                    ((row4_value_left >> 12) & 1 ? v_high : v_low) : v_low, 0, trise);
	V(in2[12]) <+ transition(($abstime >= 4n + T_dur && $abstime < 4n + Twrite_dur) ?
                    ((row4_value_right >> 12) & 1 ? v_high : v_low) : v_low, 0, trise);
	V(in1[13]) <+ transition(($abstime >= 4n + T_dur && $abstime < 4n + Twrite_dur) ?
                    ((row4_value_left >> 13) & 1 ? v_high : v_low) : v_low, 0, trise);
	V(in2[13]) <+ transition(($abstime >= 4n + T_dur && $abstime < 4n + Twrite_dur) ?
                    ((row4_value_right >> 13) & 1 ? v_high : v_low) : v_low, 0, trise);
	V(in1[14]) <+ transition(($abstime >= 4n + T_dur && $abstime < 4n + Twrite_dur) ?
                    ((row4_value_left >> 14) & 1 ? v_high : v_low) : v_low, 0, trise);
	V(in2[14]) <+ transition(($abstime >= 4n + T_dur && $abstime < 4n + Twrite_dur) ?
                    ((row4_value_right >> 14) & 1 ? v_high : v_low) : v_low, 0, trise);
	V(in1[15]) <+ transition(($abstime >= 4n + T_dur && $abstime < 4n + Twrite_dur) ?
                    ((row4_value_left >> 15) & 1 ? v_high : v_low) : v_low, 0, trise);
	V(in2[15]) <+ transition(($abstime >= 4n + T_dur && $abstime < 4n + Twrite_dur) ?
                    ((row4_value_right >> 15) & 1 ? v_high : v_low) : v_low, 0, trise);
	V(in1[16]) <+ transition(($abstime >= 4n + T_dur && $abstime < 4n + Twrite_dur) ?
                    ((row4_value_left >> 16) & 1 ? v_high : v_low) : v_low, 0, trise);
	V(in2[16]) <+ transition(($abstime >= 4n + T_dur && $abstime < 4n + Twrite_dur) ?
                    ((row4_value_right >> 16) & 1 ? v_high : v_low) : v_low, 0, trise);
	V(in1[17]) <+ transition(($abstime >= 4n + T_dur && $abstime < 4n + Twrite_dur) ?
                    ((row4_value_left >> 17) & 1 ? v_high : v_low) : v_low, 0, trise);
	V(in2[17]) <+ transition(($abstime >= 4n + T_dur && $abstime < 4n + Twrite_dur) ?
                    ((row4_value_right >> 17) & 1 ? v_high : v_low) : v_low, 0, trise);
	V(in1[18]) <+ transition(($abstime >= 4n + T_dur && $abstime < 4n + Twrite_dur) ?
                    ((row4_value_left >> 18) & 1 ? v_high : v_low) : v_low, 0, trise);
	V(in2[18]) <+ transition(($abstime >= 4n + T_dur && $abstime < 4n + Twrite_dur) ?
                    ((row4_value_right >> 18) & 1 ? v_high : v_low) : v_low, 0, trise);
	V(in1[19]) <+ transition(($abstime >= 4n + T_dur && $abstime < 4n + Twrite_dur) ?
                    ((row4_value_left >> 19) & 1 ? v_high : v_low) : v_low, 0, trise);
	V(in2[19]) <+ transition(($abstime >= 4n + T_dur && $abstime < 4n + Twrite_dur) ?
                    ((row4_value_right >> 19) & 1 ? v_high : v_low) : v_low, 0, trise);
	V(in1[20]) <+ transition(($abstime >= 4n + T_dur && $abstime < 4n + Twrite_dur) ?
                    ((row4_value_left >> 20) & 1 ? v_high : v_low) : v_low, 0, trise);
	V(in2[20]) <+ transition(($abstime >= 4n + T_dur && $abstime < 4n + Twrite_dur) ?
                    ((row4_value_right >> 20) & 1 ? v_high : v_low) : v_low, 0, trise);
	V(in1[21]) <+ transition(($abstime >= 4n + T_dur && $abstime < 4n + Twrite_dur) ?
                    ((row4_value_left >> 21) & 1 ? v_high : v_low) : v_low, 0, trise);
	V(in2[21]) <+ transition(($abstime >= 4n + T_dur && $abstime < 4n + Twrite_dur) ?
                    ((row4_value_right >> 21) & 1 ? v_high : v_low) : v_low, 0, trise);
	V(in1[22]) <+ transition(($abstime >= 4n + T_dur && $abstime < 4n + Twrite_dur) ?
                    ((row4_value_left >> 22) & 1 ? v_high : v_low) : v_low, 0, trise);
	V(in2[22]) <+ transition(($abstime >= 4n + T_dur && $abstime < 4n + Twrite_dur) ?
                    ((row4_value_right >> 22) & 1 ? v_high : v_low) : v_low, 0, trise);
	V(in1[23]) <+ transition(($abstime >= 4n + T_dur && $abstime < 4n + Twrite_dur) ?
                    ((row4_value_left >> 23) & 1 ? v_high : v_low) : v_low, 0, trise);
	V(in2[23]) <+ transition(($abstime >= 4n + T_dur && $abstime < 4n + Twrite_dur) ?
                    ((row4_value_right >> 23) & 1 ? v_high : v_low) : v_low, 0, trise);
	V(in1[24]) <+ transition(($abstime >= 4n + T_dur && $abstime < 4n + Twrite_dur) ?
                    ((row4_value_left >> 24) & 1 ? v_high : v_low) : v_low, 0, trise);
	V(in2[24]) <+ transition(($abstime >= 4n + T_dur && $abstime < 4n + Twrite_dur) ?
                    ((row4_value_right >> 24) & 1 ? v_high : v_low) : v_low, 0, trise);
	V(in1[25]) <+ transition(($abstime >= 4n + T_dur && $abstime < 4n + Twrite_dur) ?
                    ((row4_value_left >> 25) & 1 ? v_high : v_low) : v_low, 0, trise);
	V(in2[25]) <+ transition(($abstime >= 4n + T_dur && $abstime < 4n + Twrite_dur) ?
                    ((row4_value_right >> 25) & 1 ? v_high : v_low) : v_low, 0, trise);
	V(in1[26]) <+ transition(($abstime >= 4n + T_dur && $abstime < 4n + Twrite_dur) ?
                    ((row4_value_left >> 26) & 1 ? v_high : v_low) : v_low, 0, trise);
	V(in2[26]) <+ transition(($abstime >= 4n + T_dur && $abstime < 4n + Twrite_dur) ?
                    ((row4_value_right >> 26) & 1 ? v_high : v_low) : v_low, 0, trise);
	V(in1[27]) <+ transition(($abstime >= 4n + T_dur && $abstime < 4n + Twrite_dur) ?
                    ((row4_value_left >> 27) & 1 ? v_high : v_low) : v_low, 0, trise);
	V(in2[27]) <+ transition(($abstime >= 4n + T_dur && $abstime < 4n + Twrite_dur) ?
                    ((row4_value_right >> 27) & 1 ? v_high : v_low) : v_low, 0, trise);
	V(in1[28]) <+ transition(($abstime >= 4n + T_dur && $abstime < 4n + Twrite_dur) ?
                    ((row4_value_left >> 28) & 1 ? v_high : v_low) : v_low, 0, trise);
	V(in2[28]) <+ transition(($abstime >= 4n + T_dur && $abstime < 4n + Twrite_dur) ?
                    ((row4_value_right >> 28) & 1 ? v_high : v_low) : v_low, 0, trise);
	V(in1[29]) <+ transition(($abstime >= 4n + T_dur && $abstime < 4n + Twrite_dur) ?
                    ((row4_value_left >> 29) & 1 ? v_high : v_low) : v_low, 0, trise);
	V(in2[29]) <+ transition(($abstime >= 4n + T_dur && $abstime < 4n + Twrite_dur) ?
                    ((row4_value_right >> 29) & 1 ? v_high : v_low) : v_low, 0, trise);
	V(in1[30]) <+ transition(($abstime >= 4n + T_dur && $abstime < 4n + Twrite_dur) ?
                    ((row4_value_left >> 30) & 1 ? v_high : v_low) : v_low, 0, trise);
	V(in2[30]) <+ transition(($abstime >= 4n + T_dur && $abstime < 4n + Twrite_dur) ?
                    ((row4_value_right >> 30) & 1 ? v_high : v_low) : v_low, 0, trise);
	V(in1[31]) <+ transition(($abstime >= 4n + T_dur && $abstime < 4n + Twrite_dur) ?
                    ((row4_value_left >> 31) & 1 ? v_high : v_low) : v_low, 0, trise);
	V(in2[31]) <+ transition(($abstime >= 4n + T_dur && $abstime < 4n + Twrite_dur) ?
                    ((row4_value_right >> 31) & 1 ? v_high : v_low) : v_low, 0, trise);

    V(write) <+ transition(($abstime >= 5n + T_dur && $abstime < 5n + Twrite_dur) ? v_high : v_low, 0, trise);
    V(WL[5]) <+ transition(($abstime >= 5n + T_dur && $abstime < 5n + TWL_dur) ? v_high : v_low, 0, trise);
	V(in1[0]) <+ transition(($abstime >= 5n + T_dur && $abstime < 5n + Twrite_dur) ?
                    ((row5_value_left >> 0) & 1 ? v_high : v_low) : v_low, 0, trise);
	V(in2[0]) <+ transition(($abstime >= 5n + T_dur && $abstime < 5n + Twrite_dur) ?
                    ((row5_value_right >> 0) & 1 ? v_high : v_low) : v_low, 0, trise);
	V(in1[1]) <+ transition(($abstime >= 5n + T_dur && $abstime < 5n + Twrite_dur) ?
                    ((row5_value_left >> 1) & 1 ? v_high : v_low) : v_low, 0, trise);
	V(in2[1]) <+ transition(($abstime >= 5n + T_dur && $abstime < 5n + Twrite_dur) ?
                    ((row5_value_right >> 1) & 1 ? v_high : v_low) : v_low, 0, trise);
	V(in1[2]) <+ transition(($abstime >= 5n + T_dur && $abstime < 5n + Twrite_dur) ?
                    ((row5_value_left >> 2) & 1 ? v_high : v_low) : v_low, 0, trise);
	V(in2[2]) <+ transition(($abstime >= 5n + T_dur && $abstime < 5n + Twrite_dur) ?
                    ((row5_value_right >> 2) & 1 ? v_high : v_low) : v_low, 0, trise);
	V(in1[3]) <+ transition(($abstime >= 5n + T_dur && $abstime < 5n + Twrite_dur) ?
                    ((row5_value_left >> 3) & 1 ? v_high : v_low) : v_low, 0, trise);
	V(in2[3]) <+ transition(($abstime >= 5n + T_dur && $abstime < 5n + Twrite_dur) ?
                    ((row5_value_right >> 3) & 1 ? v_high : v_low) : v_low, 0, trise);
	V(in1[4]) <+ transition(($abstime >= 5n + T_dur && $abstime < 5n + Twrite_dur) ?
                    ((row5_value_left >> 4) & 1 ? v_high : v_low) : v_low, 0, trise);
	V(in2[4]) <+ transition(($abstime >= 5n + T_dur && $abstime < 5n + Twrite_dur) ?
                    ((row5_value_right >> 4) & 1 ? v_high : v_low) : v_low, 0, trise);
	V(in1[5]) <+ transition(($abstime >= 5n + T_dur && $abstime < 5n + Twrite_dur) ?
                    ((row5_value_left >> 5) & 1 ? v_high : v_low) : v_low, 0, trise);
	V(in2[5]) <+ transition(($abstime >= 5n + T_dur && $abstime < 5n + Twrite_dur) ?
                    ((row5_value_right >> 5) & 1 ? v_high : v_low) : v_low, 0, trise);
	V(in1[6]) <+ transition(($abstime >= 5n + T_dur && $abstime < 5n + Twrite_dur) ?
                    ((row5_value_left >> 6) & 1 ? v_high : v_low) : v_low, 0, trise);
	V(in2[6]) <+ transition(($abstime >= 5n + T_dur && $abstime < 5n + Twrite_dur) ?
                    ((row5_value_right >> 6) & 1 ? v_high : v_low) : v_low, 0, trise);
	V(in1[7]) <+ transition(($abstime >= 5n + T_dur && $abstime < 5n + Twrite_dur) ?
                    ((row5_value_left >> 7) & 1 ? v_high : v_low) : v_low, 0, trise);
	V(in2[7]) <+ transition(($abstime >= 5n + T_dur && $abstime < 5n + Twrite_dur) ?
                    ((row5_value_right >> 7) & 1 ? v_high : v_low) : v_low, 0, trise);
	V(in1[8]) <+ transition(($abstime >= 5n + T_dur && $abstime < 5n + Twrite_dur) ?
                    ((row5_value_left >> 8) & 1 ? v_high : v_low) : v_low, 0, trise);
	V(in2[8]) <+ transition(($abstime >= 5n + T_dur && $abstime < 5n + Twrite_dur) ?
                    ((row5_value_right >> 8) & 1 ? v_high : v_low) : v_low, 0, trise);
	V(in1[9]) <+ transition(($abstime >= 5n + T_dur && $abstime < 5n + Twrite_dur) ?
                    ((row5_value_left >> 9) & 1 ? v_high : v_low) : v_low, 0, trise);
	V(in2[9]) <+ transition(($abstime >= 5n + T_dur && $abstime < 5n + Twrite_dur) ?
                    ((row5_value_right >> 9) & 1 ? v_high : v_low) : v_low, 0, trise);
	V(in1[10]) <+ transition(($abstime >= 5n + T_dur && $abstime < 5n + Twrite_dur) ?
                    ((row5_value_left >> 10) & 1 ? v_high : v_low) : v_low, 0, trise);
	V(in2[10]) <+ transition(($abstime >= 5n + T_dur && $abstime < 5n + Twrite_dur) ?
                    ((row5_value_right >> 10) & 1 ? v_high : v_low) : v_low, 0, trise);
	V(in1[11]) <+ transition(($abstime >= 5n + T_dur && $abstime < 5n + Twrite_dur) ?
                    ((row5_value_left >> 11) & 1 ? v_high : v_low) : v_low, 0, trise);
	V(in2[11]) <+ transition(($abstime >= 5n + T_dur && $abstime < 5n + Twrite_dur) ?
                    ((row5_value_right >> 11) & 1 ? v_high : v_low) : v_low, 0, trise);
	V(in1[12]) <+ transition(($abstime >= 5n + T_dur && $abstime < 5n + Twrite_dur) ?
                    ((row5_value_left >> 12) & 1 ? v_high : v_low) : v_low, 0, trise);
	V(in2[12]) <+ transition(($abstime >= 5n + T_dur && $abstime < 5n + Twrite_dur) ?
                    ((row5_value_right >> 12) & 1 ? v_high : v_low) : v_low, 0, trise);
	V(in1[13]) <+ transition(($abstime >= 5n + T_dur && $abstime < 5n + Twrite_dur) ?
                    ((row5_value_left >> 13) & 1 ? v_high : v_low) : v_low, 0, trise);
	V(in2[13]) <+ transition(($abstime >= 5n + T_dur && $abstime < 5n + Twrite_dur) ?
                    ((row5_value_right >> 13) & 1 ? v_high : v_low) : v_low, 0, trise);
	V(in1[14]) <+ transition(($abstime >= 5n + T_dur && $abstime < 5n + Twrite_dur) ?
                    ((row5_value_left >> 14) & 1 ? v_high : v_low) : v_low, 0, trise);
	V(in2[14]) <+ transition(($abstime >= 5n + T_dur && $abstime < 5n + Twrite_dur) ?
                    ((row5_value_right >> 14) & 1 ? v_high : v_low) : v_low, 0, trise);
	V(in1[15]) <+ transition(($abstime >= 5n + T_dur && $abstime < 5n + Twrite_dur) ?
                    ((row5_value_left >> 15) & 1 ? v_high : v_low) : v_low, 0, trise);
	V(in2[15]) <+ transition(($abstime >= 5n + T_dur && $abstime < 5n + Twrite_dur) ?
                    ((row5_value_right >> 15) & 1 ? v_high : v_low) : v_low, 0, trise);
	V(in1[16]) <+ transition(($abstime >= 5n + T_dur && $abstime < 5n + Twrite_dur) ?
                    ((row5_value_left >> 16) & 1 ? v_high : v_low) : v_low, 0, trise);
	V(in2[16]) <+ transition(($abstime >= 5n + T_dur && $abstime < 5n + Twrite_dur) ?
                    ((row5_value_right >> 16) & 1 ? v_high : v_low) : v_low, 0, trise);
	V(in1[17]) <+ transition(($abstime >= 5n + T_dur && $abstime < 5n + Twrite_dur) ?
                    ((row5_value_left >> 17) & 1 ? v_high : v_low) : v_low, 0, trise);
	V(in2[17]) <+ transition(($abstime >= 5n + T_dur && $abstime < 5n + Twrite_dur) ?
                    ((row5_value_right >> 17) & 1 ? v_high : v_low) : v_low, 0, trise);
	V(in1[18]) <+ transition(($abstime >= 5n + T_dur && $abstime < 5n + Twrite_dur) ?
                    ((row5_value_left >> 18) & 1 ? v_high : v_low) : v_low, 0, trise);
	V(in2[18]) <+ transition(($abstime >= 5n + T_dur && $abstime < 5n + Twrite_dur) ?
                    ((row5_value_right >> 18) & 1 ? v_high : v_low) : v_low, 0, trise);
	V(in1[19]) <+ transition(($abstime >= 5n + T_dur && $abstime < 5n + Twrite_dur) ?
                    ((row5_value_left >> 19) & 1 ? v_high : v_low) : v_low, 0, trise);
	V(in2[19]) <+ transition(($abstime >= 5n + T_dur && $abstime < 5n + Twrite_dur) ?
                    ((row5_value_right >> 19) & 1 ? v_high : v_low) : v_low, 0, trise);
	V(in1[20]) <+ transition(($abstime >= 5n + T_dur && $abstime < 5n + Twrite_dur) ?
                    ((row5_value_left >> 20) & 1 ? v_high : v_low) : v_low, 0, trise);
	V(in2[20]) <+ transition(($abstime >= 5n + T_dur && $abstime < 5n + Twrite_dur) ?
                    ((row5_value_right >> 20) & 1 ? v_high : v_low) : v_low, 0, trise);
	V(in1[21]) <+ transition(($abstime >= 5n + T_dur && $abstime < 5n + Twrite_dur) ?
                    ((row5_value_left >> 21) & 1 ? v_high : v_low) : v_low, 0, trise);
	V(in2[21]) <+ transition(($abstime >= 5n + T_dur && $abstime < 5n + Twrite_dur) ?
                    ((row5_value_right >> 21) & 1 ? v_high : v_low) : v_low, 0, trise);
	V(in1[22]) <+ transition(($abstime >= 5n + T_dur && $abstime < 5n + Twrite_dur) ?
                    ((row5_value_left >> 22) & 1 ? v_high : v_low) : v_low, 0, trise);
	V(in2[22]) <+ transition(($abstime >= 5n + T_dur && $abstime < 5n + Twrite_dur) ?
                    ((row5_value_right >> 22) & 1 ? v_high : v_low) : v_low, 0, trise);
	V(in1[23]) <+ transition(($abstime >= 5n + T_dur && $abstime < 5n + Twrite_dur) ?
                    ((row5_value_left >> 23) & 1 ? v_high : v_low) : v_low, 0, trise);
	V(in2[23]) <+ transition(($abstime >= 5n + T_dur && $abstime < 5n + Twrite_dur) ?
                    ((row5_value_right >> 23) & 1 ? v_high : v_low) : v_low, 0, trise);
	V(in1[24]) <+ transition(($abstime >= 5n + T_dur && $abstime < 5n + Twrite_dur) ?
                    ((row5_value_left >> 24) & 1 ? v_high : v_low) : v_low, 0, trise);
	V(in2[24]) <+ transition(($abstime >= 5n + T_dur && $abstime < 5n + Twrite_dur) ?
                    ((row5_value_right >> 24) & 1 ? v_high : v_low) : v_low, 0, trise);
	V(in1[25]) <+ transition(($abstime >= 5n + T_dur && $abstime < 5n + Twrite_dur) ?
                    ((row5_value_left >> 25) & 1 ? v_high : v_low) : v_low, 0, trise);
	V(in2[25]) <+ transition(($abstime >= 5n + T_dur && $abstime < 5n + Twrite_dur) ?
                    ((row5_value_right >> 25) & 1 ? v_high : v_low) : v_low, 0, trise);
	V(in1[26]) <+ transition(($abstime >= 5n + T_dur && $abstime < 5n + Twrite_dur) ?
                    ((row5_value_left >> 26) & 1 ? v_high : v_low) : v_low, 0, trise);
	V(in2[26]) <+ transition(($abstime >= 5n + T_dur && $abstime < 5n + Twrite_dur) ?
                    ((row5_value_right >> 26) & 1 ? v_high : v_low) : v_low, 0, trise);
	V(in1[27]) <+ transition(($abstime >= 5n + T_dur && $abstime < 5n + Twrite_dur) ?
                    ((row5_value_left >> 27) & 1 ? v_high : v_low) : v_low, 0, trise);
	V(in2[27]) <+ transition(($abstime >= 5n + T_dur && $abstime < 5n + Twrite_dur) ?
                    ((row5_value_right >> 27) & 1 ? v_high : v_low) : v_low, 0, trise);
	V(in1[28]) <+ transition(($abstime >= 5n + T_dur && $abstime < 5n + Twrite_dur) ?
                    ((row5_value_left >> 28) & 1 ? v_high : v_low) : v_low, 0, trise);
	V(in2[28]) <+ transition(($abstime >= 5n + T_dur && $abstime < 5n + Twrite_dur) ?
                    ((row5_value_right >> 28) & 1 ? v_high : v_low) : v_low, 0, trise);
	V(in1[29]) <+ transition(($abstime >= 5n + T_dur && $abstime < 5n + Twrite_dur) ?
                    ((row5_value_left >> 29) & 1 ? v_high : v_low) : v_low, 0, trise);
	V(in2[29]) <+ transition(($abstime >= 5n + T_dur && $abstime < 5n + Twrite_dur) ?
                    ((row5_value_right >> 29) & 1 ? v_high : v_low) : v_low, 0, trise);
	V(in1[30]) <+ transition(($abstime >= 5n + T_dur && $abstime < 5n + Twrite_dur) ?
                    ((row5_value_left >> 30) & 1 ? v_high : v_low) : v_low, 0, trise);
	V(in2[30]) <+ transition(($abstime >= 5n + T_dur && $abstime < 5n + Twrite_dur) ?
                    ((row5_value_right >> 30) & 1 ? v_high : v_low) : v_low, 0, trise);
	V(in1[31]) <+ transition(($abstime >= 5n + T_dur && $abstime < 5n + Twrite_dur) ?
                    ((row5_value_left >> 31) & 1 ? v_high : v_low) : v_low, 0, trise);
	V(in2[31]) <+ transition(($abstime >= 5n + T_dur && $abstime < 5n + Twrite_dur) ?
                    ((row5_value_right >> 31) & 1 ? v_high : v_low) : v_low, 0, trise);

    V(write) <+ transition(($abstime >= 6n + T_dur && $abstime < 6n + Twrite_dur) ? v_high : v_low, 0, trise);
    V(WL[6]) <+ transition(($abstime >= 6n + T_dur && $abstime < 6n + TWL_dur) ? v_high : v_low, 0, trise);
	V(in1[0]) <+ transition(($abstime >= 6n + T_dur && $abstime < 6n + Twrite_dur) ?
                    ((row6_value_left >> 0) & 1 ? v_high : v_low) : v_low, 0, trise);
	V(in2[0]) <+ transition(($abstime >= 6n + T_dur && $abstime < 6n + Twrite_dur) ?
                    ((row6_value_right >> 0) & 1 ? v_high : v_low) : v_low, 0, trise);
	V(in1[1]) <+ transition(($abstime >= 6n + T_dur && $abstime < 6n + Twrite_dur) ?
                    ((row6_value_left >> 1) & 1 ? v_high : v_low) : v_low, 0, trise);
	V(in2[1]) <+ transition(($abstime >= 6n + T_dur && $abstime < 6n + Twrite_dur) ?
                    ((row6_value_right >> 1) & 1 ? v_high : v_low) : v_low, 0, trise);
	V(in1[2]) <+ transition(($abstime >= 6n + T_dur && $abstime < 6n + Twrite_dur) ?
                    ((row6_value_left >> 2) & 1 ? v_high : v_low) : v_low, 0, trise);
	V(in2[2]) <+ transition(($abstime >= 6n + T_dur && $abstime < 6n + Twrite_dur) ?
                    ((row6_value_right >> 2) & 1 ? v_high : v_low) : v_low, 0, trise);
	V(in1[3]) <+ transition(($abstime >= 6n + T_dur && $abstime < 6n + Twrite_dur) ?
                    ((row6_value_left >> 3) & 1 ? v_high : v_low) : v_low, 0, trise);
	V(in2[3]) <+ transition(($abstime >= 6n + T_dur && $abstime < 6n + Twrite_dur) ?
                    ((row6_value_right >> 3) & 1 ? v_high : v_low) : v_low, 0, trise);
	V(in1[4]) <+ transition(($abstime >= 6n + T_dur && $abstime < 6n + Twrite_dur) ?
                    ((row6_value_left >> 4) & 1 ? v_high : v_low) : v_low, 0, trise);
	V(in2[4]) <+ transition(($abstime >= 6n + T_dur && $abstime < 6n + Twrite_dur) ?
                    ((row6_value_right >> 4) & 1 ? v_high : v_low) : v_low, 0, trise);
	V(in1[5]) <+ transition(($abstime >= 6n + T_dur && $abstime < 6n + Twrite_dur) ?
                    ((row6_value_left >> 5) & 1 ? v_high : v_low) : v_low, 0, trise);
	V(in2[5]) <+ transition(($abstime >= 6n + T_dur && $abstime < 6n + Twrite_dur) ?
                    ((row6_value_right >> 5) & 1 ? v_high : v_low) : v_low, 0, trise);
	V(in1[6]) <+ transition(($abstime >= 6n + T_dur && $abstime < 6n + Twrite_dur) ?
                    ((row6_value_left >> 6) & 1 ? v_high : v_low) : v_low, 0, trise);
	V(in2[6]) <+ transition(($abstime >= 6n + T_dur && $abstime < 6n + Twrite_dur) ?
                    ((row6_value_right >> 6) & 1 ? v_high : v_low) : v_low, 0, trise);
	V(in1[7]) <+ transition(($abstime >= 6n + T_dur && $abstime < 6n + Twrite_dur) ?
                    ((row6_value_left >> 7) & 1 ? v_high : v_low) : v_low, 0, trise);
	V(in2[7]) <+ transition(($abstime >= 6n + T_dur && $abstime < 6n + Twrite_dur) ?
                    ((row6_value_right >> 7) & 1 ? v_high : v_low) : v_low, 0, trise);
	V(in1[8]) <+ transition(($abstime >= 6n + T_dur && $abstime < 6n + Twrite_dur) ?
                    ((row6_value_left >> 8) & 1 ? v_high : v_low) : v_low, 0, trise);
	V(in2[8]) <+ transition(($abstime >= 6n + T_dur && $abstime < 6n + Twrite_dur) ?
                    ((row6_value_right >> 8) & 1 ? v_high : v_low) : v_low, 0, trise);
	V(in1[9]) <+ transition(($abstime >= 6n + T_dur && $abstime < 6n + Twrite_dur) ?
                    ((row6_value_left >> 9) & 1 ? v_high : v_low) : v_low, 0, trise);
	V(in2[9]) <+ transition(($abstime >= 6n + T_dur && $abstime < 6n + Twrite_dur) ?
                    ((row6_value_right >> 9) & 1 ? v_high : v_low) : v_low, 0, trise);
	V(in1[10]) <+ transition(($abstime >= 6n + T_dur && $abstime < 6n + Twrite_dur) ?
                    ((row6_value_left >> 10) & 1 ? v_high : v_low) : v_low, 0, trise);
	V(in2[10]) <+ transition(($abstime >= 6n + T_dur && $abstime < 6n + Twrite_dur) ?
                    ((row6_value_right >> 10) & 1 ? v_high : v_low) : v_low, 0, trise);
	V(in1[11]) <+ transition(($abstime >= 6n + T_dur && $abstime < 6n + Twrite_dur) ?
                    ((row6_value_left >> 11) & 1 ? v_high : v_low) : v_low, 0, trise);
	V(in2[11]) <+ transition(($abstime >= 6n + T_dur && $abstime < 6n + Twrite_dur) ?
                    ((row6_value_right >> 11) & 1 ? v_high : v_low) : v_low, 0, trise);
	V(in1[12]) <+ transition(($abstime >= 6n + T_dur && $abstime < 6n + Twrite_dur) ?
                    ((row6_value_left >> 12) & 1 ? v_high : v_low) : v_low, 0, trise);
	V(in2[12]) <+ transition(($abstime >= 6n + T_dur && $abstime < 6n + Twrite_dur) ?
                    ((row6_value_right >> 12) & 1 ? v_high : v_low) : v_low, 0, trise);
	V(in1[13]) <+ transition(($abstime >= 6n + T_dur && $abstime < 6n + Twrite_dur) ?
                    ((row6_value_left >> 13) & 1 ? v_high : v_low) : v_low, 0, trise);
	V(in2[13]) <+ transition(($abstime >= 6n + T_dur && $abstime < 6n + Twrite_dur) ?
                    ((row6_value_right >> 13) & 1 ? v_high : v_low) : v_low, 0, trise);
	V(in1[14]) <+ transition(($abstime >= 6n + T_dur && $abstime < 6n + Twrite_dur) ?
                    ((row6_value_left >> 14) & 1 ? v_high : v_low) : v_low, 0, trise);
	V(in2[14]) <+ transition(($abstime >= 6n + T_dur && $abstime < 6n + Twrite_dur) ?
                    ((row6_value_right >> 14) & 1 ? v_high : v_low) : v_low, 0, trise);
	V(in1[15]) <+ transition(($abstime >= 6n + T_dur && $abstime < 6n + Twrite_dur) ?
                    ((row6_value_left >> 15) & 1 ? v_high : v_low) : v_low, 0, trise);
	V(in2[15]) <+ transition(($abstime >= 6n + T_dur && $abstime < 6n + Twrite_dur) ?
                    ((row6_value_right >> 15) & 1 ? v_high : v_low) : v_low, 0, trise);
	V(in1[16]) <+ transition(($abstime >= 6n + T_dur && $abstime < 6n + Twrite_dur) ?
                    ((row6_value_left >> 16) & 1 ? v_high : v_low) : v_low, 0, trise);
	V(in2[16]) <+ transition(($abstime >= 6n + T_dur && $abstime < 6n + Twrite_dur) ?
                    ((row6_value_right >> 16) & 1 ? v_high : v_low) : v_low, 0, trise);
	V(in1[17]) <+ transition(($abstime >= 6n + T_dur && $abstime < 6n + Twrite_dur) ?
                    ((row6_value_left >> 17) & 1 ? v_high : v_low) : v_low, 0, trise);
	V(in2[17]) <+ transition(($abstime >= 6n + T_dur && $abstime < 6n + Twrite_dur) ?
                    ((row6_value_right >> 17) & 1 ? v_high : v_low) : v_low, 0, trise);
	V(in1[18]) <+ transition(($abstime >= 6n + T_dur && $abstime < 6n + Twrite_dur) ?
                    ((row6_value_left >> 18) & 1 ? v_high : v_low) : v_low, 0, trise);
	V(in2[18]) <+ transition(($abstime >= 6n + T_dur && $abstime < 6n + Twrite_dur) ?
                    ((row6_value_right >> 18) & 1 ? v_high : v_low) : v_low, 0, trise);
	V(in1[19]) <+ transition(($abstime >= 6n + T_dur && $abstime < 6n + Twrite_dur) ?
                    ((row6_value_left >> 19) & 1 ? v_high : v_low) : v_low, 0, trise);
	V(in2[19]) <+ transition(($abstime >= 6n + T_dur && $abstime < 6n + Twrite_dur) ?
                    ((row6_value_right >> 19) & 1 ? v_high : v_low) : v_low, 0, trise);
	V(in1[20]) <+ transition(($abstime >= 6n + T_dur && $abstime < 6n + Twrite_dur) ?
                    ((row6_value_left >> 20) & 1 ? v_high : v_low) : v_low, 0, trise);
	V(in2[20]) <+ transition(($abstime >= 6n + T_dur && $abstime < 6n + Twrite_dur) ?
                    ((row6_value_right >> 20) & 1 ? v_high : v_low) : v_low, 0, trise);
	V(in1[21]) <+ transition(($abstime >= 6n + T_dur && $abstime < 6n + Twrite_dur) ?
                    ((row6_value_left >> 21) & 1 ? v_high : v_low) : v_low, 0, trise);
	V(in2[21]) <+ transition(($abstime >= 6n + T_dur && $abstime < 6n + Twrite_dur) ?
                    ((row6_value_right >> 21) & 1 ? v_high : v_low) : v_low, 0, trise);
	V(in1[22]) <+ transition(($abstime >= 6n + T_dur && $abstime < 6n + Twrite_dur) ?
                    ((row6_value_left >> 22) & 1 ? v_high : v_low) : v_low, 0, trise);
	V(in2[22]) <+ transition(($abstime >= 6n + T_dur && $abstime < 6n + Twrite_dur) ?
                    ((row6_value_right >> 22) & 1 ? v_high : v_low) : v_low, 0, trise);
	V(in1[23]) <+ transition(($abstime >= 6n + T_dur && $abstime < 6n + Twrite_dur) ?
                    ((row6_value_left >> 23) & 1 ? v_high : v_low) : v_low, 0, trise);
	V(in2[23]) <+ transition(($abstime >= 6n + T_dur && $abstime < 6n + Twrite_dur) ?
                    ((row6_value_right >> 23) & 1 ? v_high : v_low) : v_low, 0, trise);
	V(in1[24]) <+ transition(($abstime >= 6n + T_dur && $abstime < 6n + Twrite_dur) ?
                    ((row6_value_left >> 24) & 1 ? v_high : v_low) : v_low, 0, trise);
	V(in2[24]) <+ transition(($abstime >= 6n + T_dur && $abstime < 6n + Twrite_dur) ?
                    ((row6_value_right >> 24) & 1 ? v_high : v_low) : v_low, 0, trise);
	V(in1[25]) <+ transition(($abstime >= 6n + T_dur && $abstime < 6n + Twrite_dur) ?
                    ((row6_value_left >> 25) & 1 ? v_high : v_low) : v_low, 0, trise);
	V(in2[25]) <+ transition(($abstime >= 6n + T_dur && $abstime < 6n + Twrite_dur) ?
                    ((row6_value_right >> 25) & 1 ? v_high : v_low) : v_low, 0, trise);
	V(in1[26]) <+ transition(($abstime >= 6n + T_dur && $abstime < 6n + Twrite_dur) ?
                    ((row6_value_left >> 26) & 1 ? v_high : v_low) : v_low, 0, trise);
	V(in2[26]) <+ transition(($abstime >= 6n + T_dur && $abstime < 6n + Twrite_dur) ?
                    ((row6_value_right >> 26) & 1 ? v_high : v_low) : v_low, 0, trise);
	V(in1[27]) <+ transition(($abstime >= 6n + T_dur && $abstime < 6n + Twrite_dur) ?
                    ((row6_value_left >> 27) & 1 ? v_high : v_low) : v_low, 0, trise);
	V(in2[27]) <+ transition(($abstime >= 6n + T_dur && $abstime < 6n + Twrite_dur) ?
                    ((row6_value_right >> 27) & 1 ? v_high : v_low) : v_low, 0, trise);
	V(in1[28]) <+ transition(($abstime >= 6n + T_dur && $abstime < 6n + Twrite_dur) ?
                    ((row6_value_left >> 28) & 1 ? v_high : v_low) : v_low, 0, trise);
	V(in2[28]) <+ transition(($abstime >= 6n + T_dur && $abstime < 6n + Twrite_dur) ?
                    ((row6_value_right >> 28) & 1 ? v_high : v_low) : v_low, 0, trise);
	V(in1[29]) <+ transition(($abstime >= 6n + T_dur && $abstime < 6n + Twrite_dur) ?
                    ((row6_value_left >> 29) & 1 ? v_high : v_low) : v_low, 0, trise);
	V(in2[29]) <+ transition(($abstime >= 6n + T_dur && $abstime < 6n + Twrite_dur) ?
                    ((row6_value_right >> 29) & 1 ? v_high : v_low) : v_low, 0, trise);
	V(in1[30]) <+ transition(($abstime >= 6n + T_dur && $abstime < 6n + Twrite_dur) ?
                    ((row6_value_left >> 30) & 1 ? v_high : v_low) : v_low, 0, trise);
	V(in2[30]) <+ transition(($abstime >= 6n + T_dur && $abstime < 6n + Twrite_dur) ?
                    ((row6_value_right >> 30) & 1 ? v_high : v_low) : v_low, 0, trise);
	V(in1[31]) <+ transition(($abstime >= 6n + T_dur && $abstime < 6n + Twrite_dur) ?
                    ((row6_value_left >> 31) & 1 ? v_high : v_low) : v_low, 0, trise);
	V(in2[31]) <+ transition(($abstime >= 6n + T_dur && $abstime < 6n + Twrite_dur) ?
                    ((row6_value_right >> 31) & 1 ? v_high : v_low) : v_low, 0, trise);

    V(write) <+ transition(($abstime >= 7n + T_dur && $abstime < 7n + Twrite_dur) ? v_high : v_low, 0, trise);
    V(WL[7]) <+ transition(($abstime >= 7n + T_dur && $abstime < 7n + TWL_dur) ? v_high : v_low, 0, trise);
	V(in1[0]) <+ transition(($abstime >= 7n + T_dur && $abstime < 7n + Twrite_dur) ?
                    ((row7_value_left >> 0) & 1 ? v_high : v_low) : v_low, 0, trise);
	V(in2[0]) <+ transition(($abstime >= 7n + T_dur && $abstime < 7n + Twrite_dur) ?
                    ((row7_value_right >> 0) & 1 ? v_high : v_low) : v_low, 0, trise);
	V(in1[1]) <+ transition(($abstime >= 7n + T_dur && $abstime < 7n + Twrite_dur) ?
                    ((row7_value_left >> 1) & 1 ? v_high : v_low) : v_low, 0, trise);
	V(in2[1]) <+ transition(($abstime >= 7n + T_dur && $abstime < 7n + Twrite_dur) ?
                    ((row7_value_right >> 1) & 1 ? v_high : v_low) : v_low, 0, trise);
	V(in1[2]) <+ transition(($abstime >= 7n + T_dur && $abstime < 7n + Twrite_dur) ?
                    ((row7_value_left >> 2) & 1 ? v_high : v_low) : v_low, 0, trise);
	V(in2[2]) <+ transition(($abstime >= 7n + T_dur && $abstime < 7n + Twrite_dur) ?
                    ((row7_value_right >> 2) & 1 ? v_high : v_low) : v_low, 0, trise);
	V(in1[3]) <+ transition(($abstime >= 7n + T_dur && $abstime < 7n + Twrite_dur) ?
                    ((row7_value_left >> 3) & 1 ? v_high : v_low) : v_low, 0, trise);
	V(in2[3]) <+ transition(($abstime >= 7n + T_dur && $abstime < 7n + Twrite_dur) ?
                    ((row7_value_right >> 3) & 1 ? v_high : v_low) : v_low, 0, trise);
	V(in1[4]) <+ transition(($abstime >= 7n + T_dur && $abstime < 7n + Twrite_dur) ?
                    ((row7_value_left >> 4) & 1 ? v_high : v_low) : v_low, 0, trise);
	V(in2[4]) <+ transition(($abstime >= 7n + T_dur && $abstime < 7n + Twrite_dur) ?
                    ((row7_value_right >> 4) & 1 ? v_high : v_low) : v_low, 0, trise);
	V(in1[5]) <+ transition(($abstime >= 7n + T_dur && $abstime < 7n + Twrite_dur) ?
                    ((row7_value_left >> 5) & 1 ? v_high : v_low) : v_low, 0, trise);
	V(in2[5]) <+ transition(($abstime >= 7n + T_dur && $abstime < 7n + Twrite_dur) ?
                    ((row7_value_right >> 5) & 1 ? v_high : v_low) : v_low, 0, trise);
	V(in1[6]) <+ transition(($abstime >= 7n + T_dur && $abstime < 7n + Twrite_dur) ?
                    ((row7_value_left >> 6) & 1 ? v_high : v_low) : v_low, 0, trise);
	V(in2[6]) <+ transition(($abstime >= 7n + T_dur && $abstime < 7n + Twrite_dur) ?
                    ((row7_value_right >> 6) & 1 ? v_high : v_low) : v_low, 0, trise);
	V(in1[7]) <+ transition(($abstime >= 7n + T_dur && $abstime < 7n + Twrite_dur) ?
                    ((row7_value_left >> 7) & 1 ? v_high : v_low) : v_low, 0, trise);
	V(in2[7]) <+ transition(($abstime >= 7n + T_dur && $abstime < 7n + Twrite_dur) ?
                    ((row7_value_right >> 7) & 1 ? v_high : v_low) : v_low, 0, trise);
	V(in1[8]) <+ transition(($abstime >= 7n + T_dur && $abstime < 7n + Twrite_dur) ?
                    ((row7_value_left >> 8) & 1 ? v_high : v_low) : v_low, 0, trise);
	V(in2[8]) <+ transition(($abstime >= 7n + T_dur && $abstime < 7n + Twrite_dur) ?
                    ((row7_value_right >> 8) & 1 ? v_high : v_low) : v_low, 0, trise);
	V(in1[9]) <+ transition(($abstime >= 7n + T_dur && $abstime < 7n + Twrite_dur) ?
                    ((row7_value_left >> 9) & 1 ? v_high : v_low) : v_low, 0, trise);
	V(in2[9]) <+ transition(($abstime >= 7n + T_dur && $abstime < 7n + Twrite_dur) ?
                    ((row7_value_right >> 9) & 1 ? v_high : v_low) : v_low, 0, trise);
	V(in1[10]) <+ transition(($abstime >= 7n + T_dur && $abstime < 7n + Twrite_dur) ?
                    ((row7_value_left >> 10) & 1 ? v_high : v_low) : v_low, 0, trise);
	V(in2[10]) <+ transition(($abstime >= 7n + T_dur && $abstime < 7n + Twrite_dur) ?
                    ((row7_value_right >> 10) & 1 ? v_high : v_low) : v_low, 0, trise);
	V(in1[11]) <+ transition(($abstime >= 7n + T_dur && $abstime < 7n + Twrite_dur) ?
                    ((row7_value_left >> 11) & 1 ? v_high : v_low) : v_low, 0, trise);
	V(in2[11]) <+ transition(($abstime >= 7n + T_dur && $abstime < 7n + Twrite_dur) ?
                    ((row7_value_right >> 11) & 1 ? v_high : v_low) : v_low, 0, trise);
	V(in1[12]) <+ transition(($abstime >= 7n + T_dur && $abstime < 7n + Twrite_dur) ?
                    ((row7_value_left >> 12) & 1 ? v_high : v_low) : v_low, 0, trise);
	V(in2[12]) <+ transition(($abstime >= 7n + T_dur && $abstime < 7n + Twrite_dur) ?
                    ((row7_value_right >> 12) & 1 ? v_high : v_low) : v_low, 0, trise);
	V(in1[13]) <+ transition(($abstime >= 7n + T_dur && $abstime < 7n + Twrite_dur) ?
                    ((row7_value_left >> 13) & 1 ? v_high : v_low) : v_low, 0, trise);
	V(in2[13]) <+ transition(($abstime >= 7n + T_dur && $abstime < 7n + Twrite_dur) ?
                    ((row7_value_right >> 13) & 1 ? v_high : v_low) : v_low, 0, trise);
	V(in1[14]) <+ transition(($abstime >= 7n + T_dur && $abstime < 7n + Twrite_dur) ?
                    ((row7_value_left >> 14) & 1 ? v_high : v_low) : v_low, 0, trise);
	V(in2[14]) <+ transition(($abstime >= 7n + T_dur && $abstime < 7n + Twrite_dur) ?
                    ((row7_value_right >> 14) & 1 ? v_high : v_low) : v_low, 0, trise);
	V(in1[15]) <+ transition(($abstime >= 7n + T_dur && $abstime < 7n + Twrite_dur) ?
                    ((row7_value_left >> 15) & 1 ? v_high : v_low) : v_low, 0, trise);
	V(in2[15]) <+ transition(($abstime >= 7n + T_dur && $abstime < 7n + Twrite_dur) ?
                    ((row7_value_right >> 15) & 1 ? v_high : v_low) : v_low, 0, trise);
	V(in1[16]) <+ transition(($abstime >= 7n + T_dur && $abstime < 7n + Twrite_dur) ?
                    ((row7_value_left >> 16) & 1 ? v_high : v_low) : v_low, 0, trise);
	V(in2[16]) <+ transition(($abstime >= 7n + T_dur && $abstime < 7n + Twrite_dur) ?
                    ((row7_value_right >> 16) & 1 ? v_high : v_low) : v_low, 0, trise);
	V(in1[17]) <+ transition(($abstime >= 7n + T_dur && $abstime < 7n + Twrite_dur) ?
                    ((row7_value_left >> 17) & 1 ? v_high : v_low) : v_low, 0, trise);
	V(in2[17]) <+ transition(($abstime >= 7n + T_dur && $abstime < 7n + Twrite_dur) ?
                    ((row7_value_right >> 17) & 1 ? v_high : v_low) : v_low, 0, trise);
	V(in1[18]) <+ transition(($abstime >= 7n + T_dur && $abstime < 7n + Twrite_dur) ?
                    ((row7_value_left >> 18) & 1 ? v_high : v_low) : v_low, 0, trise);
	V(in2[18]) <+ transition(($abstime >= 7n + T_dur && $abstime < 7n + Twrite_dur) ?
                    ((row7_value_right >> 18) & 1 ? v_high : v_low) : v_low, 0, trise);
	V(in1[19]) <+ transition(($abstime >= 7n + T_dur && $abstime < 7n + Twrite_dur) ?
                    ((row7_value_left >> 19) & 1 ? v_high : v_low) : v_low, 0, trise);
	V(in2[19]) <+ transition(($abstime >= 7n + T_dur && $abstime < 7n + Twrite_dur) ?
                    ((row7_value_right >> 19) & 1 ? v_high : v_low) : v_low, 0, trise);
	V(in1[20]) <+ transition(($abstime >= 7n + T_dur && $abstime < 7n + Twrite_dur) ?
                    ((row7_value_left >> 20) & 1 ? v_high : v_low) : v_low, 0, trise);
	V(in2[20]) <+ transition(($abstime >= 7n + T_dur && $abstime < 7n + Twrite_dur) ?
                    ((row7_value_right >> 20) & 1 ? v_high : v_low) : v_low, 0, trise);
	V(in1[21]) <+ transition(($abstime >= 7n + T_dur && $abstime < 7n + Twrite_dur) ?
                    ((row7_value_left >> 21) & 1 ? v_high : v_low) : v_low, 0, trise);
	V(in2[21]) <+ transition(($abstime >= 7n + T_dur && $abstime < 7n + Twrite_dur) ?
                    ((row7_value_right >> 21) & 1 ? v_high : v_low) : v_low, 0, trise);
	V(in1[22]) <+ transition(($abstime >= 7n + T_dur && $abstime < 7n + Twrite_dur) ?
                    ((row7_value_left >> 22) & 1 ? v_high : v_low) : v_low, 0, trise);
	V(in2[22]) <+ transition(($abstime >= 7n + T_dur && $abstime < 7n + Twrite_dur) ?
                    ((row7_value_right >> 22) & 1 ? v_high : v_low) : v_low, 0, trise);
	V(in1[23]) <+ transition(($abstime >= 7n + T_dur && $abstime < 7n + Twrite_dur) ?
                    ((row7_value_left >> 23) & 1 ? v_high : v_low) : v_low, 0, trise);
	V(in2[23]) <+ transition(($abstime >= 7n + T_dur && $abstime < 7n + Twrite_dur) ?
                    ((row7_value_right >> 23) & 1 ? v_high : v_low) : v_low, 0, trise);
	V(in1[24]) <+ transition(($abstime >= 7n + T_dur && $abstime < 7n + Twrite_dur) ?
                    ((row7_value_left >> 24) & 1 ? v_high : v_low) : v_low, 0, trise);
	V(in2[24]) <+ transition(($abstime >= 7n + T_dur && $abstime < 7n + Twrite_dur) ?
                    ((row7_value_right >> 24) & 1 ? v_high : v_low) : v_low, 0, trise);
	V(in1[25]) <+ transition(($abstime >= 7n + T_dur && $abstime < 7n + Twrite_dur) ?
                    ((row7_value_left >> 25) & 1 ? v_high : v_low) : v_low, 0, trise);
	V(in2[25]) <+ transition(($abstime >= 7n + T_dur && $abstime < 7n + Twrite_dur) ?
                    ((row7_value_right >> 25) & 1 ? v_high : v_low) : v_low, 0, trise);
	V(in1[26]) <+ transition(($abstime >= 7n + T_dur && $abstime < 7n + Twrite_dur) ?
                    ((row7_value_left >> 26) & 1 ? v_high : v_low) : v_low, 0, trise);
	V(in2[26]) <+ transition(($abstime >= 7n + T_dur && $abstime < 7n + Twrite_dur) ?
                    ((row7_value_right >> 26) & 1 ? v_high : v_low) : v_low, 0, trise);
	V(in1[27]) <+ transition(($abstime >= 7n + T_dur && $abstime < 7n + Twrite_dur) ?
                    ((row7_value_left >> 27) & 1 ? v_high : v_low) : v_low, 0, trise);
	V(in2[27]) <+ transition(($abstime >= 7n + T_dur && $abstime < 7n + Twrite_dur) ?
                    ((row7_value_right >> 27) & 1 ? v_high : v_low) : v_low, 0, trise);
	V(in1[28]) <+ transition(($abstime >= 7n + T_dur && $abstime < 7n + Twrite_dur) ?
                    ((row7_value_left >> 28) & 1 ? v_high : v_low) : v_low, 0, trise);
	V(in2[28]) <+ transition(($abstime >= 7n + T_dur && $abstime < 7n + Twrite_dur) ?
                    ((row7_value_right >> 28) & 1 ? v_high : v_low) : v_low, 0, trise);
	V(in1[29]) <+ transition(($abstime >= 7n + T_dur && $abstime < 7n + Twrite_dur) ?
                    ((row7_value_left >> 29) & 1 ? v_high : v_low) : v_low, 0, trise);
	V(in2[29]) <+ transition(($abstime >= 7n + T_dur && $abstime < 7n + Twrite_dur) ?
                    ((row7_value_right >> 29) & 1 ? v_high : v_low) : v_low, 0, trise);
	V(in1[30]) <+ transition(($abstime >= 7n + T_dur && $abstime < 7n + Twrite_dur) ?
                    ((row7_value_left >> 30) & 1 ? v_high : v_low) : v_low, 0, trise);
	V(in2[30]) <+ transition(($abstime >= 7n + T_dur && $abstime < 7n + Twrite_dur) ?
                    ((row7_value_right >> 30) & 1 ? v_high : v_low) : v_low, 0, trise);
	V(in1[31]) <+ transition(($abstime >= 7n + T_dur && $abstime < 7n + Twrite_dur) ?
                    ((row7_value_left >> 31) & 1 ? v_high : v_low) : v_low, 0, trise);
	V(in2[31]) <+ transition(($abstime >= 7n + T_dur && $abstime < 7n + Twrite_dur) ?
                    ((row7_value_right >> 31) & 1 ? v_high : v_low) : v_low, 0, trise);

    V(write) <+ transition(($abstime >= 8n + T_dur && $abstime < 8n + Twrite_dur) ? v_high : v_low, 0, trise);
    V(WL[8]) <+ transition(($abstime >= 8n + T_dur && $abstime < 8n + TWL_dur) ? v_high : v_low, 0, trise);
	V(in1[0]) <+ transition(($abstime >= 8n + T_dur && $abstime < 8n + Twrite_dur) ?
                    ((row8_value_left >> 0) & 1 ? v_high : v_low) : v_low, 0, trise);
	V(in2[0]) <+ transition(($abstime >= 8n + T_dur && $abstime < 8n + Twrite_dur) ?
                    ((row8_value_right >> 0) & 1 ? v_high : v_low) : v_low, 0, trise);
	V(in1[1]) <+ transition(($abstime >= 8n + T_dur && $abstime < 8n + Twrite_dur) ?
                    ((row8_value_left >> 1) & 1 ? v_high : v_low) : v_low, 0, trise);
	V(in2[1]) <+ transition(($abstime >= 8n + T_dur && $abstime < 8n + Twrite_dur) ?
                    ((row8_value_right >> 1) & 1 ? v_high : v_low) : v_low, 0, trise);
	V(in1[2]) <+ transition(($abstime >= 8n + T_dur && $abstime < 8n + Twrite_dur) ?
                    ((row8_value_left >> 2) & 1 ? v_high : v_low) : v_low, 0, trise);
	V(in2[2]) <+ transition(($abstime >= 8n + T_dur && $abstime < 8n + Twrite_dur) ?
                    ((row8_value_right >> 2) & 1 ? v_high : v_low) : v_low, 0, trise);
	V(in1[3]) <+ transition(($abstime >= 8n + T_dur && $abstime < 8n + Twrite_dur) ?
                    ((row8_value_left >> 3) & 1 ? v_high : v_low) : v_low, 0, trise);
	V(in2[3]) <+ transition(($abstime >= 8n + T_dur && $abstime < 8n + Twrite_dur) ?
                    ((row8_value_right >> 3) & 1 ? v_high : v_low) : v_low, 0, trise);
	V(in1[4]) <+ transition(($abstime >= 8n + T_dur && $abstime < 8n + Twrite_dur) ?
                    ((row8_value_left >> 4) & 1 ? v_high : v_low) : v_low, 0, trise);
	V(in2[4]) <+ transition(($abstime >= 8n + T_dur && $abstime < 8n + Twrite_dur) ?
                    ((row8_value_right >> 4) & 1 ? v_high : v_low) : v_low, 0, trise);
	V(in1[5]) <+ transition(($abstime >= 8n + T_dur && $abstime < 8n + Twrite_dur) ?
                    ((row8_value_left >> 5) & 1 ? v_high : v_low) : v_low, 0, trise);
	V(in2[5]) <+ transition(($abstime >= 8n + T_dur && $abstime < 8n + Twrite_dur) ?
                    ((row8_value_right >> 5) & 1 ? v_high : v_low) : v_low, 0, trise);
	V(in1[6]) <+ transition(($abstime >= 8n + T_dur && $abstime < 8n + Twrite_dur) ?
                    ((row8_value_left >> 6) & 1 ? v_high : v_low) : v_low, 0, trise);
	V(in2[6]) <+ transition(($abstime >= 8n + T_dur && $abstime < 8n + Twrite_dur) ?
                    ((row8_value_right >> 6) & 1 ? v_high : v_low) : v_low, 0, trise);
	V(in1[7]) <+ transition(($abstime >= 8n + T_dur && $abstime < 8n + Twrite_dur) ?
                    ((row8_value_left >> 7) & 1 ? v_high : v_low) : v_low, 0, trise);
	V(in2[7]) <+ transition(($abstime >= 8n + T_dur && $abstime < 8n + Twrite_dur) ?
                    ((row8_value_right >> 7) & 1 ? v_high : v_low) : v_low, 0, trise);
	V(in1[8]) <+ transition(($abstime >= 8n + T_dur && $abstime < 8n + Twrite_dur) ?
                    ((row8_value_left >> 8) & 1 ? v_high : v_low) : v_low, 0, trise);
	V(in2[8]) <+ transition(($abstime >= 8n + T_dur && $abstime < 8n + Twrite_dur) ?
                    ((row8_value_right >> 8) & 1 ? v_high : v_low) : v_low, 0, trise);
	V(in1[9]) <+ transition(($abstime >= 8n + T_dur && $abstime < 8n + Twrite_dur) ?
                    ((row8_value_left >> 9) & 1 ? v_high : v_low) : v_low, 0, trise);
	V(in2[9]) <+ transition(($abstime >= 8n + T_dur && $abstime < 8n + Twrite_dur) ?
                    ((row8_value_right >> 9) & 1 ? v_high : v_low) : v_low, 0, trise);
	V(in1[10]) <+ transition(($abstime >= 8n + T_dur && $abstime < 8n + Twrite_dur) ?
                    ((row8_value_left >> 10) & 1 ? v_high : v_low) : v_low, 0, trise);
	V(in2[10]) <+ transition(($abstime >= 8n + T_dur && $abstime < 8n + Twrite_dur) ?
                    ((row8_value_right >> 10) & 1 ? v_high : v_low) : v_low, 0, trise);
	V(in1[11]) <+ transition(($abstime >= 8n + T_dur && $abstime < 8n + Twrite_dur) ?
                    ((row8_value_left >> 11) & 1 ? v_high : v_low) : v_low, 0, trise);
	V(in2[11]) <+ transition(($abstime >= 8n + T_dur && $abstime < 8n + Twrite_dur) ?
                    ((row8_value_right >> 11) & 1 ? v_high : v_low) : v_low, 0, trise);
	V(in1[12]) <+ transition(($abstime >= 8n + T_dur && $abstime < 8n + Twrite_dur) ?
                    ((row8_value_left >> 12) & 1 ? v_high : v_low) : v_low, 0, trise);
	V(in2[12]) <+ transition(($abstime >= 8n + T_dur && $abstime < 8n + Twrite_dur) ?
                    ((row8_value_right >> 12) & 1 ? v_high : v_low) : v_low, 0, trise);
	V(in1[13]) <+ transition(($abstime >= 8n + T_dur && $abstime < 8n + Twrite_dur) ?
                    ((row8_value_left >> 13) & 1 ? v_high : v_low) : v_low, 0, trise);
	V(in2[13]) <+ transition(($abstime >= 8n + T_dur && $abstime < 8n + Twrite_dur) ?
                    ((row8_value_right >> 13) & 1 ? v_high : v_low) : v_low, 0, trise);
	V(in1[14]) <+ transition(($abstime >= 8n + T_dur && $abstime < 8n + Twrite_dur) ?
                    ((row8_value_left >> 14) & 1 ? v_high : v_low) : v_low, 0, trise);
	V(in2[14]) <+ transition(($abstime >= 8n + T_dur && $abstime < 8n + Twrite_dur) ?
                    ((row8_value_right >> 14) & 1 ? v_high : v_low) : v_low, 0, trise);
	V(in1[15]) <+ transition(($abstime >= 8n + T_dur && $abstime < 8n + Twrite_dur) ?
                    ((row8_value_left >> 15) & 1 ? v_high : v_low) : v_low, 0, trise);
	V(in2[15]) <+ transition(($abstime >= 8n + T_dur && $abstime < 8n + Twrite_dur) ?
                    ((row8_value_right >> 15) & 1 ? v_high : v_low) : v_low, 0, trise);
	V(in1[16]) <+ transition(($abstime >= 8n + T_dur && $abstime < 8n + Twrite_dur) ?
                    ((row8_value_left >> 16) & 1 ? v_high : v_low) : v_low, 0, trise);
	V(in2[16]) <+ transition(($abstime >= 8n + T_dur && $abstime < 8n + Twrite_dur) ?
                    ((row8_value_right >> 16) & 1 ? v_high : v_low) : v_low, 0, trise);
	V(in1[17]) <+ transition(($abstime >= 8n + T_dur && $abstime < 8n + Twrite_dur) ?
                    ((row8_value_left >> 17) & 1 ? v_high : v_low) : v_low, 0, trise);
	V(in2[17]) <+ transition(($abstime >= 8n + T_dur && $abstime < 8n + Twrite_dur) ?
                    ((row8_value_right >> 17) & 1 ? v_high : v_low) : v_low, 0, trise);
	V(in1[18]) <+ transition(($abstime >= 8n + T_dur && $abstime < 8n + Twrite_dur) ?
                    ((row8_value_left >> 18) & 1 ? v_high : v_low) : v_low, 0, trise);
	V(in2[18]) <+ transition(($abstime >= 8n + T_dur && $abstime < 8n + Twrite_dur) ?
                    ((row8_value_right >> 18) & 1 ? v_high : v_low) : v_low, 0, trise);
	V(in1[19]) <+ transition(($abstime >= 8n + T_dur && $abstime < 8n + Twrite_dur) ?
                    ((row8_value_left >> 19) & 1 ? v_high : v_low) : v_low, 0, trise);
	V(in2[19]) <+ transition(($abstime >= 8n + T_dur && $abstime < 8n + Twrite_dur) ?
                    ((row8_value_right >> 19) & 1 ? v_high : v_low) : v_low, 0, trise);
	V(in1[20]) <+ transition(($abstime >= 8n + T_dur && $abstime < 8n + Twrite_dur) ?
                    ((row8_value_left >> 20) & 1 ? v_high : v_low) : v_low, 0, trise);
	V(in2[20]) <+ transition(($abstime >= 8n + T_dur && $abstime < 8n + Twrite_dur) ?
                    ((row8_value_right >> 20) & 1 ? v_high : v_low) : v_low, 0, trise);
	V(in1[21]) <+ transition(($abstime >= 8n + T_dur && $abstime < 8n + Twrite_dur) ?
                    ((row8_value_left >> 21) & 1 ? v_high : v_low) : v_low, 0, trise);
	V(in2[21]) <+ transition(($abstime >= 8n + T_dur && $abstime < 8n + Twrite_dur) ?
                    ((row8_value_right >> 21) & 1 ? v_high : v_low) : v_low, 0, trise);
	V(in1[22]) <+ transition(($abstime >= 8n + T_dur && $abstime < 8n + Twrite_dur) ?
                    ((row8_value_left >> 22) & 1 ? v_high : v_low) : v_low, 0, trise);
	V(in2[22]) <+ transition(($abstime >= 8n + T_dur && $abstime < 8n + Twrite_dur) ?
                    ((row8_value_right >> 22) & 1 ? v_high : v_low) : v_low, 0, trise);
	V(in1[23]) <+ transition(($abstime >= 8n + T_dur && $abstime < 8n + Twrite_dur) ?
                    ((row8_value_left >> 23) & 1 ? v_high : v_low) : v_low, 0, trise);
	V(in2[23]) <+ transition(($abstime >= 8n + T_dur && $abstime < 8n + Twrite_dur) ?
                    ((row8_value_right >> 23) & 1 ? v_high : v_low) : v_low, 0, trise);
	V(in1[24]) <+ transition(($abstime >= 8n + T_dur && $abstime < 8n + Twrite_dur) ?
                    ((row8_value_left >> 24) & 1 ? v_high : v_low) : v_low, 0, trise);
	V(in2[24]) <+ transition(($abstime >= 8n + T_dur && $abstime < 8n + Twrite_dur) ?
                    ((row8_value_right >> 24) & 1 ? v_high : v_low) : v_low, 0, trise);
	V(in1[25]) <+ transition(($abstime >= 8n + T_dur && $abstime < 8n + Twrite_dur) ?
                    ((row8_value_left >> 25) & 1 ? v_high : v_low) : v_low, 0, trise);
	V(in2[25]) <+ transition(($abstime >= 8n + T_dur && $abstime < 8n + Twrite_dur) ?
                    ((row8_value_right >> 25) & 1 ? v_high : v_low) : v_low, 0, trise);
	V(in1[26]) <+ transition(($abstime >= 8n + T_dur && $abstime < 8n + Twrite_dur) ?
                    ((row8_value_left >> 26) & 1 ? v_high : v_low) : v_low, 0, trise);
	V(in2[26]) <+ transition(($abstime >= 8n + T_dur && $abstime < 8n + Twrite_dur) ?
                    ((row8_value_right >> 26) & 1 ? v_high : v_low) : v_low, 0, trise);
	V(in1[27]) <+ transition(($abstime >= 8n + T_dur && $abstime < 8n + Twrite_dur) ?
                    ((row8_value_left >> 27) & 1 ? v_high : v_low) : v_low, 0, trise);
	V(in2[27]) <+ transition(($abstime >= 8n + T_dur && $abstime < 8n + Twrite_dur) ?
                    ((row8_value_right >> 27) & 1 ? v_high : v_low) : v_low, 0, trise);
	V(in1[28]) <+ transition(($abstime >= 8n + T_dur && $abstime < 8n + Twrite_dur) ?
                    ((row8_value_left >> 28) & 1 ? v_high : v_low) : v_low, 0, trise);
	V(in2[28]) <+ transition(($abstime >= 8n + T_dur && $abstime < 8n + Twrite_dur) ?
                    ((row8_value_right >> 28) & 1 ? v_high : v_low) : v_low, 0, trise);
	V(in1[29]) <+ transition(($abstime >= 8n + T_dur && $abstime < 8n + Twrite_dur) ?
                    ((row8_value_left >> 29) & 1 ? v_high : v_low) : v_low, 0, trise);
	V(in2[29]) <+ transition(($abstime >= 8n + T_dur && $abstime < 8n + Twrite_dur) ?
                    ((row8_value_right >> 29) & 1 ? v_high : v_low) : v_low, 0, trise);
	V(in1[30]) <+ transition(($abstime >= 8n + T_dur && $abstime < 8n + Twrite_dur) ?
                    ((row8_value_left >> 30) & 1 ? v_high : v_low) : v_low, 0, trise);
	V(in2[30]) <+ transition(($abstime >= 8n + T_dur && $abstime < 8n + Twrite_dur) ?
                    ((row8_value_right >> 30) & 1 ? v_high : v_low) : v_low, 0, trise);
	V(in1[31]) <+ transition(($abstime >= 8n + T_dur && $abstime < 8n + Twrite_dur) ?
                    ((row8_value_left >> 31) & 1 ? v_high : v_low) : v_low, 0, trise);
	V(in2[31]) <+ transition(($abstime >= 8n + T_dur && $abstime < 8n + Twrite_dur) ?
                    ((row8_value_right >> 31) & 1 ? v_high : v_low) : v_low, 0, trise);

    V(write) <+ transition(($abstime >= 9n + T_dur && $abstime < 9n + Twrite_dur) ? v_high : v_low, 0, trise);
    V(WL[9]) <+ transition(($abstime >= 9n + T_dur && $abstime < 9n + TWL_dur) ? v_high : v_low, 0, trise);
	V(in1[0]) <+ transition(($abstime >= 9n + T_dur && $abstime < 9n + Twrite_dur) ?
                    ((row9_value_left >> 0) & 1 ? v_high : v_low) : v_low, 0, trise);
	V(in2[0]) <+ transition(($abstime >= 9n + T_dur && $abstime < 9n + Twrite_dur) ?
                    ((row9_value_right >> 0) & 1 ? v_high : v_low) : v_low, 0, trise);
	V(in1[1]) <+ transition(($abstime >= 9n + T_dur && $abstime < 9n + Twrite_dur) ?
                    ((row9_value_left >> 1) & 1 ? v_high : v_low) : v_low, 0, trise);
	V(in2[1]) <+ transition(($abstime >= 9n + T_dur && $abstime < 9n + Twrite_dur) ?
                    ((row9_value_right >> 1) & 1 ? v_high : v_low) : v_low, 0, trise);
	V(in1[2]) <+ transition(($abstime >= 9n + T_dur && $abstime < 9n + Twrite_dur) ?
                    ((row9_value_left >> 2) & 1 ? v_high : v_low) : v_low, 0, trise);
	V(in2[2]) <+ transition(($abstime >= 9n + T_dur && $abstime < 9n + Twrite_dur) ?
                    ((row9_value_right >> 2) & 1 ? v_high : v_low) : v_low, 0, trise);
	V(in1[3]) <+ transition(($abstime >= 9n + T_dur && $abstime < 9n + Twrite_dur) ?
                    ((row9_value_left >> 3) & 1 ? v_high : v_low) : v_low, 0, trise);
	V(in2[3]) <+ transition(($abstime >= 9n + T_dur && $abstime < 9n + Twrite_dur) ?
                    ((row9_value_right >> 3) & 1 ? v_high : v_low) : v_low, 0, trise);
	V(in1[4]) <+ transition(($abstime >= 9n + T_dur && $abstime < 9n + Twrite_dur) ?
                    ((row9_value_left >> 4) & 1 ? v_high : v_low) : v_low, 0, trise);
	V(in2[4]) <+ transition(($abstime >= 9n + T_dur && $abstime < 9n + Twrite_dur) ?
                    ((row9_value_right >> 4) & 1 ? v_high : v_low) : v_low, 0, trise);
	V(in1[5]) <+ transition(($abstime >= 9n + T_dur && $abstime < 9n + Twrite_dur) ?
                    ((row9_value_left >> 5) & 1 ? v_high : v_low) : v_low, 0, trise);
	V(in2[5]) <+ transition(($abstime >= 9n + T_dur && $abstime < 9n + Twrite_dur) ?
                    ((row9_value_right >> 5) & 1 ? v_high : v_low) : v_low, 0, trise);
	V(in1[6]) <+ transition(($abstime >= 9n + T_dur && $abstime < 9n + Twrite_dur) ?
                    ((row9_value_left >> 6) & 1 ? v_high : v_low) : v_low, 0, trise);
	V(in2[6]) <+ transition(($abstime >= 9n + T_dur && $abstime < 9n + Twrite_dur) ?
                    ((row9_value_right >> 6) & 1 ? v_high : v_low) : v_low, 0, trise);
	V(in1[7]) <+ transition(($abstime >= 9n + T_dur && $abstime < 9n + Twrite_dur) ?
                    ((row9_value_left >> 7) & 1 ? v_high : v_low) : v_low, 0, trise);
	V(in2[7]) <+ transition(($abstime >= 9n + T_dur && $abstime < 9n + Twrite_dur) ?
                    ((row9_value_right >> 7) & 1 ? v_high : v_low) : v_low, 0, trise);
	V(in1[8]) <+ transition(($abstime >= 9n + T_dur && $abstime < 9n + Twrite_dur) ?
                    ((row9_value_left >> 8) & 1 ? v_high : v_low) : v_low, 0, trise);
	V(in2[8]) <+ transition(($abstime >= 9n + T_dur && $abstime < 9n + Twrite_dur) ?
                    ((row9_value_right >> 8) & 1 ? v_high : v_low) : v_low, 0, trise);
	V(in1[9]) <+ transition(($abstime >= 9n + T_dur && $abstime < 9n + Twrite_dur) ?
                    ((row9_value_left >> 9) & 1 ? v_high : v_low) : v_low, 0, trise);
	V(in2[9]) <+ transition(($abstime >= 9n + T_dur && $abstime < 9n + Twrite_dur) ?
                    ((row9_value_right >> 9) & 1 ? v_high : v_low) : v_low, 0, trise);
	V(in1[10]) <+ transition(($abstime >= 9n + T_dur && $abstime < 9n + Twrite_dur) ?
                    ((row9_value_left >> 10) & 1 ? v_high : v_low) : v_low, 0, trise);
	V(in2[10]) <+ transition(($abstime >= 9n + T_dur && $abstime < 9n + Twrite_dur) ?
                    ((row9_value_right >> 10) & 1 ? v_high : v_low) : v_low, 0, trise);
	V(in1[11]) <+ transition(($abstime >= 9n + T_dur && $abstime < 9n + Twrite_dur) ?
                    ((row9_value_left >> 11) & 1 ? v_high : v_low) : v_low, 0, trise);
	V(in2[11]) <+ transition(($abstime >= 9n + T_dur && $abstime < 9n + Twrite_dur) ?
                    ((row9_value_right >> 11) & 1 ? v_high : v_low) : v_low, 0, trise);
	V(in1[12]) <+ transition(($abstime >= 9n + T_dur && $abstime < 9n + Twrite_dur) ?
                    ((row9_value_left >> 12) & 1 ? v_high : v_low) : v_low, 0, trise);
	V(in2[12]) <+ transition(($abstime >= 9n + T_dur && $abstime < 9n + Twrite_dur) ?
                    ((row9_value_right >> 12) & 1 ? v_high : v_low) : v_low, 0, trise);
	V(in1[13]) <+ transition(($abstime >= 9n + T_dur && $abstime < 9n + Twrite_dur) ?
                    ((row9_value_left >> 13) & 1 ? v_high : v_low) : v_low, 0, trise);
	V(in2[13]) <+ transition(($abstime >= 9n + T_dur && $abstime < 9n + Twrite_dur) ?
                    ((row9_value_right >> 13) & 1 ? v_high : v_low) : v_low, 0, trise);
	V(in1[14]) <+ transition(($abstime >= 9n + T_dur && $abstime < 9n + Twrite_dur) ?
                    ((row9_value_left >> 14) & 1 ? v_high : v_low) : v_low, 0, trise);
	V(in2[14]) <+ transition(($abstime >= 9n + T_dur && $abstime < 9n + Twrite_dur) ?
                    ((row9_value_right >> 14) & 1 ? v_high : v_low) : v_low, 0, trise);
	V(in1[15]) <+ transition(($abstime >= 9n + T_dur && $abstime < 9n + Twrite_dur) ?
                    ((row9_value_left >> 15) & 1 ? v_high : v_low) : v_low, 0, trise);
	V(in2[15]) <+ transition(($abstime >= 9n + T_dur && $abstime < 9n + Twrite_dur) ?
                    ((row9_value_right >> 15) & 1 ? v_high : v_low) : v_low, 0, trise);
	V(in1[16]) <+ transition(($abstime >= 9n + T_dur && $abstime < 9n + Twrite_dur) ?
                    ((row9_value_left >> 16) & 1 ? v_high : v_low) : v_low, 0, trise);
	V(in2[16]) <+ transition(($abstime >= 9n + T_dur && $abstime < 9n + Twrite_dur) ?
                    ((row9_value_right >> 16) & 1 ? v_high : v_low) : v_low, 0, trise);
	V(in1[17]) <+ transition(($abstime >= 9n + T_dur && $abstime < 9n + Twrite_dur) ?
                    ((row9_value_left >> 17) & 1 ? v_high : v_low) : v_low, 0, trise);
	V(in2[17]) <+ transition(($abstime >= 9n + T_dur && $abstime < 9n + Twrite_dur) ?
                    ((row9_value_right >> 17) & 1 ? v_high : v_low) : v_low, 0, trise);
	V(in1[18]) <+ transition(($abstime >= 9n + T_dur && $abstime < 9n + Twrite_dur) ?
                    ((row9_value_left >> 18) & 1 ? v_high : v_low) : v_low, 0, trise);
	V(in2[18]) <+ transition(($abstime >= 9n + T_dur && $abstime < 9n + Twrite_dur) ?
                    ((row9_value_right >> 18) & 1 ? v_high : v_low) : v_low, 0, trise);
	V(in1[19]) <+ transition(($abstime >= 9n + T_dur && $abstime < 9n + Twrite_dur) ?
                    ((row9_value_left >> 19) & 1 ? v_high : v_low) : v_low, 0, trise);
	V(in2[19]) <+ transition(($abstime >= 9n + T_dur && $abstime < 9n + Twrite_dur) ?
                    ((row9_value_right >> 19) & 1 ? v_high : v_low) : v_low, 0, trise);
	V(in1[20]) <+ transition(($abstime >= 9n + T_dur && $abstime < 9n + Twrite_dur) ?
                    ((row9_value_left >> 20) & 1 ? v_high : v_low) : v_low, 0, trise);
	V(in2[20]) <+ transition(($abstime >= 9n + T_dur && $abstime < 9n + Twrite_dur) ?
                    ((row9_value_right >> 20) & 1 ? v_high : v_low) : v_low, 0, trise);
	V(in1[21]) <+ transition(($abstime >= 9n + T_dur && $abstime < 9n + Twrite_dur) ?
                    ((row9_value_left >> 21) & 1 ? v_high : v_low) : v_low, 0, trise);
	V(in2[21]) <+ transition(($abstime >= 9n + T_dur && $abstime < 9n + Twrite_dur) ?
                    ((row9_value_right >> 21) & 1 ? v_high : v_low) : v_low, 0, trise);
	V(in1[22]) <+ transition(($abstime >= 9n + T_dur && $abstime < 9n + Twrite_dur) ?
                    ((row9_value_left >> 22) & 1 ? v_high : v_low) : v_low, 0, trise);
	V(in2[22]) <+ transition(($abstime >= 9n + T_dur && $abstime < 9n + Twrite_dur) ?
                    ((row9_value_right >> 22) & 1 ? v_high : v_low) : v_low, 0, trise);
	V(in1[23]) <+ transition(($abstime >= 9n + T_dur && $abstime < 9n + Twrite_dur) ?
                    ((row9_value_left >> 23) & 1 ? v_high : v_low) : v_low, 0, trise);
	V(in2[23]) <+ transition(($abstime >= 9n + T_dur && $abstime < 9n + Twrite_dur) ?
                    ((row9_value_right >> 23) & 1 ? v_high : v_low) : v_low, 0, trise);
	V(in1[24]) <+ transition(($abstime >= 9n + T_dur && $abstime < 9n + Twrite_dur) ?
                    ((row9_value_left >> 24) & 1 ? v_high : v_low) : v_low, 0, trise);
	V(in2[24]) <+ transition(($abstime >= 9n + T_dur && $abstime < 9n + Twrite_dur) ?
                    ((row9_value_right >> 24) & 1 ? v_high : v_low) : v_low, 0, trise);
	V(in1[25]) <+ transition(($abstime >= 9n + T_dur && $abstime < 9n + Twrite_dur) ?
                    ((row9_value_left >> 25) & 1 ? v_high : v_low) : v_low, 0, trise);
	V(in2[25]) <+ transition(($abstime >= 9n + T_dur && $abstime < 9n + Twrite_dur) ?
                    ((row9_value_right >> 25) & 1 ? v_high : v_low) : v_low, 0, trise);
	V(in1[26]) <+ transition(($abstime >= 9n + T_dur && $abstime < 9n + Twrite_dur) ?
                    ((row9_value_left >> 26) & 1 ? v_high : v_low) : v_low, 0, trise);
	V(in2[26]) <+ transition(($abstime >= 9n + T_dur && $abstime < 9n + Twrite_dur) ?
                    ((row9_value_right >> 26) & 1 ? v_high : v_low) : v_low, 0, trise);
	V(in1[27]) <+ transition(($abstime >= 9n + T_dur && $abstime < 9n + Twrite_dur) ?
                    ((row9_value_left >> 27) & 1 ? v_high : v_low) : v_low, 0, trise);
	V(in2[27]) <+ transition(($abstime >= 9n + T_dur && $abstime < 9n + Twrite_dur) ?
                    ((row9_value_right >> 27) & 1 ? v_high : v_low) : v_low, 0, trise);
	V(in1[28]) <+ transition(($abstime >= 9n + T_dur && $abstime < 9n + Twrite_dur) ?
                    ((row9_value_left >> 28) & 1 ? v_high : v_low) : v_low, 0, trise);
	V(in2[28]) <+ transition(($abstime >= 9n + T_dur && $abstime < 9n + Twrite_dur) ?
                    ((row9_value_right >> 28) & 1 ? v_high : v_low) : v_low, 0, trise);
	V(in1[29]) <+ transition(($abstime >= 9n + T_dur && $abstime < 9n + Twrite_dur) ?
                    ((row9_value_left >> 29) & 1 ? v_high : v_low) : v_low, 0, trise);
	V(in2[29]) <+ transition(($abstime >= 9n + T_dur && $abstime < 9n + Twrite_dur) ?
                    ((row9_value_right >> 29) & 1 ? v_high : v_low) : v_low, 0, trise);
	V(in1[30]) <+ transition(($abstime >= 9n + T_dur && $abstime < 9n + Twrite_dur) ?
                    ((row9_value_left >> 30) & 1 ? v_high : v_low) : v_low, 0, trise);
	V(in2[30]) <+ transition(($abstime >= 9n + T_dur && $abstime < 9n + Twrite_dur) ?
                    ((row9_value_right >> 30) & 1 ? v_high : v_low) : v_low, 0, trise);
	V(in1[31]) <+ transition(($abstime >= 9n + T_dur && $abstime < 9n + Twrite_dur) ?
                    ((row9_value_left >> 31) & 1 ? v_high : v_low) : v_low, 0, trise);
	V(in2[31]) <+ transition(($abstime >= 9n + T_dur && $abstime < 9n + Twrite_dur) ?
                    ((row9_value_right >> 31) & 1 ? v_high : v_low) : v_low, 0, trise);

    V(write) <+ transition(($abstime >= 10n + T_dur && $abstime < 10n + Twrite_dur) ? v_high : v_low, 0, trise);
    V(WL[10]) <+ transition(($abstime >= 10n + T_dur && $abstime < 10n + TWL_dur) ? v_high : v_low, 0, trise);
	V(in1[0]) <+ transition(($abstime >= 10n + T_dur && $abstime < 10n + Twrite_dur) ?
                    ((row10_value_left >> 0) & 1 ? v_high : v_low) : v_low, 0, trise);
	V(in2[0]) <+ transition(($abstime >= 10n + T_dur && $abstime < 10n + Twrite_dur) ?
                    ((row10_value_right >> 0) & 1 ? v_high : v_low) : v_low, 0, trise);
	V(in1[1]) <+ transition(($abstime >= 10n + T_dur && $abstime < 10n + Twrite_dur) ?
                    ((row10_value_left >> 1) & 1 ? v_high : v_low) : v_low, 0, trise);
	V(in2[1]) <+ transition(($abstime >= 10n + T_dur && $abstime < 10n + Twrite_dur) ?
                    ((row10_value_right >> 1) & 1 ? v_high : v_low) : v_low, 0, trise);
	V(in1[2]) <+ transition(($abstime >= 10n + T_dur && $abstime < 10n + Twrite_dur) ?
                    ((row10_value_left >> 2) & 1 ? v_high : v_low) : v_low, 0, trise);
	V(in2[2]) <+ transition(($abstime >= 10n + T_dur && $abstime < 10n + Twrite_dur) ?
                    ((row10_value_right >> 2) & 1 ? v_high : v_low) : v_low, 0, trise);
	V(in1[3]) <+ transition(($abstime >= 10n + T_dur && $abstime < 10n + Twrite_dur) ?
                    ((row10_value_left >> 3) & 1 ? v_high : v_low) : v_low, 0, trise);
	V(in2[3]) <+ transition(($abstime >= 10n + T_dur && $abstime < 10n + Twrite_dur) ?
                    ((row10_value_right >> 3) & 1 ? v_high : v_low) : v_low, 0, trise);
	V(in1[4]) <+ transition(($abstime >= 10n + T_dur && $abstime < 10n + Twrite_dur) ?
                    ((row10_value_left >> 4) & 1 ? v_high : v_low) : v_low, 0, trise);
	V(in2[4]) <+ transition(($abstime >= 10n + T_dur && $abstime < 10n + Twrite_dur) ?
                    ((row10_value_right >> 4) & 1 ? v_high : v_low) : v_low, 0, trise);
	V(in1[5]) <+ transition(($abstime >= 10n + T_dur && $abstime < 10n + Twrite_dur) ?
                    ((row10_value_left >> 5) & 1 ? v_high : v_low) : v_low, 0, trise);
	V(in2[5]) <+ transition(($abstime >= 10n + T_dur && $abstime < 10n + Twrite_dur) ?
                    ((row10_value_right >> 5) & 1 ? v_high : v_low) : v_low, 0, trise);
	V(in1[6]) <+ transition(($abstime >= 10n + T_dur && $abstime < 10n + Twrite_dur) ?
                    ((row10_value_left >> 6) & 1 ? v_high : v_low) : v_low, 0, trise);
	V(in2[6]) <+ transition(($abstime >= 10n + T_dur && $abstime < 10n + Twrite_dur) ?
                    ((row10_value_right >> 6) & 1 ? v_high : v_low) : v_low, 0, trise);
	V(in1[7]) <+ transition(($abstime >= 10n + T_dur && $abstime < 10n + Twrite_dur) ?
                    ((row10_value_left >> 7) & 1 ? v_high : v_low) : v_low, 0, trise);
	V(in2[7]) <+ transition(($abstime >= 10n + T_dur && $abstime < 10n + Twrite_dur) ?
                    ((row10_value_right >> 7) & 1 ? v_high : v_low) : v_low, 0, trise);
	V(in1[8]) <+ transition(($abstime >= 10n + T_dur && $abstime < 10n + Twrite_dur) ?
                    ((row10_value_left >> 8) & 1 ? v_high : v_low) : v_low, 0, trise);
	V(in2[8]) <+ transition(($abstime >= 10n + T_dur && $abstime < 10n + Twrite_dur) ?
                    ((row10_value_right >> 8) & 1 ? v_high : v_low) : v_low, 0, trise);
	V(in1[9]) <+ transition(($abstime >= 10n + T_dur && $abstime < 10n + Twrite_dur) ?
                    ((row10_value_left >> 9) & 1 ? v_high : v_low) : v_low, 0, trise);
	V(in2[9]) <+ transition(($abstime >= 10n + T_dur && $abstime < 10n + Twrite_dur) ?
                    ((row10_value_right >> 9) & 1 ? v_high : v_low) : v_low, 0, trise);
	V(in1[10]) <+ transition(($abstime >= 10n + T_dur && $abstime < 10n + Twrite_dur) ?
                    ((row10_value_left >> 10) & 1 ? v_high : v_low) : v_low, 0, trise);
	V(in2[10]) <+ transition(($abstime >= 10n + T_dur && $abstime < 10n + Twrite_dur) ?
                    ((row10_value_right >> 10) & 1 ? v_high : v_low) : v_low, 0, trise);
	V(in1[11]) <+ transition(($abstime >= 10n + T_dur && $abstime < 10n + Twrite_dur) ?
                    ((row10_value_left >> 11) & 1 ? v_high : v_low) : v_low, 0, trise);
	V(in2[11]) <+ transition(($abstime >= 10n + T_dur && $abstime < 10n + Twrite_dur) ?
                    ((row10_value_right >> 11) & 1 ? v_high : v_low) : v_low, 0, trise);
	V(in1[12]) <+ transition(($abstime >= 10n + T_dur && $abstime < 10n + Twrite_dur) ?
                    ((row10_value_left >> 12) & 1 ? v_high : v_low) : v_low, 0, trise);
	V(in2[12]) <+ transition(($abstime >= 10n + T_dur && $abstime < 10n + Twrite_dur) ?
                    ((row10_value_right >> 12) & 1 ? v_high : v_low) : v_low, 0, trise);
	V(in1[13]) <+ transition(($abstime >= 10n + T_dur && $abstime < 10n + Twrite_dur) ?
                    ((row10_value_left >> 13) & 1 ? v_high : v_low) : v_low, 0, trise);
	V(in2[13]) <+ transition(($abstime >= 10n + T_dur && $abstime < 10n + Twrite_dur) ?
                    ((row10_value_right >> 13) & 1 ? v_high : v_low) : v_low, 0, trise);
	V(in1[14]) <+ transition(($abstime >= 10n + T_dur && $abstime < 10n + Twrite_dur) ?
                    ((row10_value_left >> 14) & 1 ? v_high : v_low) : v_low, 0, trise);
	V(in2[14]) <+ transition(($abstime >= 10n + T_dur && $abstime < 10n + Twrite_dur) ?
                    ((row10_value_right >> 14) & 1 ? v_high : v_low) : v_low, 0, trise);
	V(in1[15]) <+ transition(($abstime >= 10n + T_dur && $abstime < 10n + Twrite_dur) ?
                    ((row10_value_left >> 15) & 1 ? v_high : v_low) : v_low, 0, trise);
	V(in2[15]) <+ transition(($abstime >= 10n + T_dur && $abstime < 10n + Twrite_dur) ?
                    ((row10_value_right >> 15) & 1 ? v_high : v_low) : v_low, 0, trise);
	V(in1[16]) <+ transition(($abstime >= 10n + T_dur && $abstime < 10n + Twrite_dur) ?
                    ((row10_value_left >> 16) & 1 ? v_high : v_low) : v_low, 0, trise);
	V(in2[16]) <+ transition(($abstime >= 10n + T_dur && $abstime < 10n + Twrite_dur) ?
                    ((row10_value_right >> 16) & 1 ? v_high : v_low) : v_low, 0, trise);
	V(in1[17]) <+ transition(($abstime >= 10n + T_dur && $abstime < 10n + Twrite_dur) ?
                    ((row10_value_left >> 17) & 1 ? v_high : v_low) : v_low, 0, trise);
	V(in2[17]) <+ transition(($abstime >= 10n + T_dur && $abstime < 10n + Twrite_dur) ?
                    ((row10_value_right >> 17) & 1 ? v_high : v_low) : v_low, 0, trise);
	V(in1[18]) <+ transition(($abstime >= 10n + T_dur && $abstime < 10n + Twrite_dur) ?
                    ((row10_value_left >> 18) & 1 ? v_high : v_low) : v_low, 0, trise);
	V(in2[18]) <+ transition(($abstime >= 10n + T_dur && $abstime < 10n + Twrite_dur) ?
                    ((row10_value_right >> 18) & 1 ? v_high : v_low) : v_low, 0, trise);
	V(in1[19]) <+ transition(($abstime >= 10n + T_dur && $abstime < 10n + Twrite_dur) ?
                    ((row10_value_left >> 19) & 1 ? v_high : v_low) : v_low, 0, trise);
	V(in2[19]) <+ transition(($abstime >= 10n + T_dur && $abstime < 10n + Twrite_dur) ?
                    ((row10_value_right >> 19) & 1 ? v_high : v_low) : v_low, 0, trise);
	V(in1[20]) <+ transition(($abstime >= 10n + T_dur && $abstime < 10n + Twrite_dur) ?
                    ((row10_value_left >> 20) & 1 ? v_high : v_low) : v_low, 0, trise);
	V(in2[20]) <+ transition(($abstime >= 10n + T_dur && $abstime < 10n + Twrite_dur) ?
                    ((row10_value_right >> 20) & 1 ? v_high : v_low) : v_low, 0, trise);
	V(in1[21]) <+ transition(($abstime >= 10n + T_dur && $abstime < 10n + Twrite_dur) ?
                    ((row10_value_left >> 21) & 1 ? v_high : v_low) : v_low, 0, trise);
	V(in2[21]) <+ transition(($abstime >= 10n + T_dur && $abstime < 10n + Twrite_dur) ?
                    ((row10_value_right >> 21) & 1 ? v_high : v_low) : v_low, 0, trise);
	V(in1[22]) <+ transition(($abstime >= 10n + T_dur && $abstime < 10n + Twrite_dur) ?
                    ((row10_value_left >> 22) & 1 ? v_high : v_low) : v_low, 0, trise);
	V(in2[22]) <+ transition(($abstime >= 10n + T_dur && $abstime < 10n + Twrite_dur) ?
                    ((row10_value_right >> 22) & 1 ? v_high : v_low) : v_low, 0, trise);
	V(in1[23]) <+ transition(($abstime >= 10n + T_dur && $abstime < 10n + Twrite_dur) ?
                    ((row10_value_left >> 23) & 1 ? v_high : v_low) : v_low, 0, trise);
	V(in2[23]) <+ transition(($abstime >= 10n + T_dur && $abstime < 10n + Twrite_dur) ?
                    ((row10_value_right >> 23) & 1 ? v_high : v_low) : v_low, 0, trise);
	V(in1[24]) <+ transition(($abstime >= 10n + T_dur && $abstime < 10n + Twrite_dur) ?
                    ((row10_value_left >> 24) & 1 ? v_high : v_low) : v_low, 0, trise);
	V(in2[24]) <+ transition(($abstime >= 10n + T_dur && $abstime < 10n + Twrite_dur) ?
                    ((row10_value_right >> 24) & 1 ? v_high : v_low) : v_low, 0, trise);
	V(in1[25]) <+ transition(($abstime >= 10n + T_dur && $abstime < 10n + Twrite_dur) ?
                    ((row10_value_left >> 25) & 1 ? v_high : v_low) : v_low, 0, trise);
	V(in2[25]) <+ transition(($abstime >= 10n + T_dur && $abstime < 10n + Twrite_dur) ?
                    ((row10_value_right >> 25) & 1 ? v_high : v_low) : v_low, 0, trise);
	V(in1[26]) <+ transition(($abstime >= 10n + T_dur && $abstime < 10n + Twrite_dur) ?
                    ((row10_value_left >> 26) & 1 ? v_high : v_low) : v_low, 0, trise);
	V(in2[26]) <+ transition(($abstime >= 10n + T_dur && $abstime < 10n + Twrite_dur) ?
                    ((row10_value_right >> 26) & 1 ? v_high : v_low) : v_low, 0, trise);
	V(in1[27]) <+ transition(($abstime >= 10n + T_dur && $abstime < 10n + Twrite_dur) ?
                    ((row10_value_left >> 27) & 1 ? v_high : v_low) : v_low, 0, trise);
	V(in2[27]) <+ transition(($abstime >= 10n + T_dur && $abstime < 10n + Twrite_dur) ?
                    ((row10_value_right >> 27) & 1 ? v_high : v_low) : v_low, 0, trise);
	V(in1[28]) <+ transition(($abstime >= 10n + T_dur && $abstime < 10n + Twrite_dur) ?
                    ((row10_value_left >> 28) & 1 ? v_high : v_low) : v_low, 0, trise);
	V(in2[28]) <+ transition(($abstime >= 10n + T_dur && $abstime < 10n + Twrite_dur) ?
                    ((row10_value_right >> 28) & 1 ? v_high : v_low) : v_low, 0, trise);
	V(in1[29]) <+ transition(($abstime >= 10n + T_dur && $abstime < 10n + Twrite_dur) ?
                    ((row10_value_left >> 29) & 1 ? v_high : v_low) : v_low, 0, trise);
	V(in2[29]) <+ transition(($abstime >= 10n + T_dur && $abstime < 10n + Twrite_dur) ?
                    ((row10_value_right >> 29) & 1 ? v_high : v_low) : v_low, 0, trise);
	V(in1[30]) <+ transition(($abstime >= 10n + T_dur && $abstime < 10n + Twrite_dur) ?
                    ((row10_value_left >> 30) & 1 ? v_high : v_low) : v_low, 0, trise);
	V(in2[30]) <+ transition(($abstime >= 10n + T_dur && $abstime < 10n + Twrite_dur) ?
                    ((row10_value_right >> 30) & 1 ? v_high : v_low) : v_low, 0, trise);
	V(in1[31]) <+ transition(($abstime >= 10n + T_dur && $abstime < 10n + Twrite_dur) ?
                    ((row10_value_left >> 31) & 1 ? v_high : v_low) : v_low, 0, trise);
	V(in2[31]) <+ transition(($abstime >= 10n + T_dur && $abstime < 10n + Twrite_dur) ?
                    ((row10_value_right >> 31) & 1 ? v_high : v_low) : v_low, 0, trise);

    V(write) <+ transition(($abstime >= 11n + T_dur && $abstime < 11n + Twrite_dur) ? v_high : v_low, 0, trise);
    V(WL[11]) <+ transition(($abstime >= 11n + T_dur && $abstime < 11n + TWL_dur) ? v_high : v_low, 0, trise);
	V(in1[0]) <+ transition(($abstime >= 11n + T_dur && $abstime < 11n + Twrite_dur) ?
                    ((row11_value_left >> 0) & 1 ? v_high : v_low) : v_low, 0, trise);
	V(in2[0]) <+ transition(($abstime >= 11n + T_dur && $abstime < 11n + Twrite_dur) ?
                    ((row11_value_right >> 0) & 1 ? v_high : v_low) : v_low, 0, trise);
	V(in1[1]) <+ transition(($abstime >= 11n + T_dur && $abstime < 11n + Twrite_dur) ?
                    ((row11_value_left >> 1) & 1 ? v_high : v_low) : v_low, 0, trise);
	V(in2[1]) <+ transition(($abstime >= 11n + T_dur && $abstime < 11n + Twrite_dur) ?
                    ((row11_value_right >> 1) & 1 ? v_high : v_low) : v_low, 0, trise);
	V(in1[2]) <+ transition(($abstime >= 11n + T_dur && $abstime < 11n + Twrite_dur) ?
                    ((row11_value_left >> 2) & 1 ? v_high : v_low) : v_low, 0, trise);
	V(in2[2]) <+ transition(($abstime >= 11n + T_dur && $abstime < 11n + Twrite_dur) ?
                    ((row11_value_right >> 2) & 1 ? v_high : v_low) : v_low, 0, trise);
	V(in1[3]) <+ transition(($abstime >= 11n + T_dur && $abstime < 11n + Twrite_dur) ?
                    ((row11_value_left >> 3) & 1 ? v_high : v_low) : v_low, 0, trise);
	V(in2[3]) <+ transition(($abstime >= 11n + T_dur && $abstime < 11n + Twrite_dur) ?
                    ((row11_value_right >> 3) & 1 ? v_high : v_low) : v_low, 0, trise);
	V(in1[4]) <+ transition(($abstime >= 11n + T_dur && $abstime < 11n + Twrite_dur) ?
                    ((row11_value_left >> 4) & 1 ? v_high : v_low) : v_low, 0, trise);
	V(in2[4]) <+ transition(($abstime >= 11n + T_dur && $abstime < 11n + Twrite_dur) ?
                    ((row11_value_right >> 4) & 1 ? v_high : v_low) : v_low, 0, trise);
	V(in1[5]) <+ transition(($abstime >= 11n + T_dur && $abstime < 11n + Twrite_dur) ?
                    ((row11_value_left >> 5) & 1 ? v_high : v_low) : v_low, 0, trise);
	V(in2[5]) <+ transition(($abstime >= 11n + T_dur && $abstime < 11n + Twrite_dur) ?
                    ((row11_value_right >> 5) & 1 ? v_high : v_low) : v_low, 0, trise);
	V(in1[6]) <+ transition(($abstime >= 11n + T_dur && $abstime < 11n + Twrite_dur) ?
                    ((row11_value_left >> 6) & 1 ? v_high : v_low) : v_low, 0, trise);
	V(in2[6]) <+ transition(($abstime >= 11n + T_dur && $abstime < 11n + Twrite_dur) ?
                    ((row11_value_right >> 6) & 1 ? v_high : v_low) : v_low, 0, trise);
	V(in1[7]) <+ transition(($abstime >= 11n + T_dur && $abstime < 11n + Twrite_dur) ?
                    ((row11_value_left >> 7) & 1 ? v_high : v_low) : v_low, 0, trise);
	V(in2[7]) <+ transition(($abstime >= 11n + T_dur && $abstime < 11n + Twrite_dur) ?
                    ((row11_value_right >> 7) & 1 ? v_high : v_low) : v_low, 0, trise);
	V(in1[8]) <+ transition(($abstime >= 11n + T_dur && $abstime < 11n + Twrite_dur) ?
                    ((row11_value_left >> 8) & 1 ? v_high : v_low) : v_low, 0, trise);
	V(in2[8]) <+ transition(($abstime >= 11n + T_dur && $abstime < 11n + Twrite_dur) ?
                    ((row11_value_right >> 8) & 1 ? v_high : v_low) : v_low, 0, trise);
	V(in1[9]) <+ transition(($abstime >= 11n + T_dur && $abstime < 11n + Twrite_dur) ?
                    ((row11_value_left >> 9) & 1 ? v_high : v_low) : v_low, 0, trise);
	V(in2[9]) <+ transition(($abstime >= 11n + T_dur && $abstime < 11n + Twrite_dur) ?
                    ((row11_value_right >> 9) & 1 ? v_high : v_low) : v_low, 0, trise);
	V(in1[10]) <+ transition(($abstime >= 11n + T_dur && $abstime < 11n + Twrite_dur) ?
                    ((row11_value_left >> 10) & 1 ? v_high : v_low) : v_low, 0, trise);
	V(in2[10]) <+ transition(($abstime >= 11n + T_dur && $abstime < 11n + Twrite_dur) ?
                    ((row11_value_right >> 10) & 1 ? v_high : v_low) : v_low, 0, trise);
	V(in1[11]) <+ transition(($abstime >= 11n + T_dur && $abstime < 11n + Twrite_dur) ?
                    ((row11_value_left >> 11) & 1 ? v_high : v_low) : v_low, 0, trise);
	V(in2[11]) <+ transition(($abstime >= 11n + T_dur && $abstime < 11n + Twrite_dur) ?
                    ((row11_value_right >> 11) & 1 ? v_high : v_low) : v_low, 0, trise);
	V(in1[12]) <+ transition(($abstime >= 11n + T_dur && $abstime < 11n + Twrite_dur) ?
                    ((row11_value_left >> 12) & 1 ? v_high : v_low) : v_low, 0, trise);
	V(in2[12]) <+ transition(($abstime >= 11n + T_dur && $abstime < 11n + Twrite_dur) ?
                    ((row11_value_right >> 12) & 1 ? v_high : v_low) : v_low, 0, trise);
	V(in1[13]) <+ transition(($abstime >= 11n + T_dur && $abstime < 11n + Twrite_dur) ?
                    ((row11_value_left >> 13) & 1 ? v_high : v_low) : v_low, 0, trise);
	V(in2[13]) <+ transition(($abstime >= 11n + T_dur && $abstime < 11n + Twrite_dur) ?
                    ((row11_value_right >> 13) & 1 ? v_high : v_low) : v_low, 0, trise);
	V(in1[14]) <+ transition(($abstime >= 11n + T_dur && $abstime < 11n + Twrite_dur) ?
                    ((row11_value_left >> 14) & 1 ? v_high : v_low) : v_low, 0, trise);
	V(in2[14]) <+ transition(($abstime >= 11n + T_dur && $abstime < 11n + Twrite_dur) ?
                    ((row11_value_right >> 14) & 1 ? v_high : v_low) : v_low, 0, trise);
	V(in1[15]) <+ transition(($abstime >= 11n + T_dur && $abstime < 11n + Twrite_dur) ?
                    ((row11_value_left >> 15) & 1 ? v_high : v_low) : v_low, 0, trise);
	V(in2[15]) <+ transition(($abstime >= 11n + T_dur && $abstime < 11n + Twrite_dur) ?
                    ((row11_value_right >> 15) & 1 ? v_high : v_low) : v_low, 0, trise);
	V(in1[16]) <+ transition(($abstime >= 11n + T_dur && $abstime < 11n + Twrite_dur) ?
                    ((row11_value_left >> 16) & 1 ? v_high : v_low) : v_low, 0, trise);
	V(in2[16]) <+ transition(($abstime >= 11n + T_dur && $abstime < 11n + Twrite_dur) ?
                    ((row11_value_right >> 16) & 1 ? v_high : v_low) : v_low, 0, trise);
	V(in1[17]) <+ transition(($abstime >= 11n + T_dur && $abstime < 11n + Twrite_dur) ?
                    ((row11_value_left >> 17) & 1 ? v_high : v_low) : v_low, 0, trise);
	V(in2[17]) <+ transition(($abstime >= 11n + T_dur && $abstime < 11n + Twrite_dur) ?
                    ((row11_value_right >> 17) & 1 ? v_high : v_low) : v_low, 0, trise);
	V(in1[18]) <+ transition(($abstime >= 11n + T_dur && $abstime < 11n + Twrite_dur) ?
                    ((row11_value_left >> 18) & 1 ? v_high : v_low) : v_low, 0, trise);
	V(in2[18]) <+ transition(($abstime >= 11n + T_dur && $abstime < 11n + Twrite_dur) ?
                    ((row11_value_right >> 18) & 1 ? v_high : v_low) : v_low, 0, trise);
	V(in1[19]) <+ transition(($abstime >= 11n + T_dur && $abstime < 11n + Twrite_dur) ?
                    ((row11_value_left >> 19) & 1 ? v_high : v_low) : v_low, 0, trise);
	V(in2[19]) <+ transition(($abstime >= 11n + T_dur && $abstime < 11n + Twrite_dur) ?
                    ((row11_value_right >> 19) & 1 ? v_high : v_low) : v_low, 0, trise);
	V(in1[20]) <+ transition(($abstime >= 11n + T_dur && $abstime < 11n + Twrite_dur) ?
                    ((row11_value_left >> 20) & 1 ? v_high : v_low) : v_low, 0, trise);
	V(in2[20]) <+ transition(($abstime >= 11n + T_dur && $abstime < 11n + Twrite_dur) ?
                    ((row11_value_right >> 20) & 1 ? v_high : v_low) : v_low, 0, trise);
	V(in1[21]) <+ transition(($abstime >= 11n + T_dur && $abstime < 11n + Twrite_dur) ?
                    ((row11_value_left >> 21) & 1 ? v_high : v_low) : v_low, 0, trise);
	V(in2[21]) <+ transition(($abstime >= 11n + T_dur && $abstime < 11n + Twrite_dur) ?
                    ((row11_value_right >> 21) & 1 ? v_high : v_low) : v_low, 0, trise);
	V(in1[22]) <+ transition(($abstime >= 11n + T_dur && $abstime < 11n + Twrite_dur) ?
                    ((row11_value_left >> 22) & 1 ? v_high : v_low) : v_low, 0, trise);
	V(in2[22]) <+ transition(($abstime >= 11n + T_dur && $abstime < 11n + Twrite_dur) ?
                    ((row11_value_right >> 22) & 1 ? v_high : v_low) : v_low, 0, trise);
	V(in1[23]) <+ transition(($abstime >= 11n + T_dur && $abstime < 11n + Twrite_dur) ?
                    ((row11_value_left >> 23) & 1 ? v_high : v_low) : v_low, 0, trise);
	V(in2[23]) <+ transition(($abstime >= 11n + T_dur && $abstime < 11n + Twrite_dur) ?
                    ((row11_value_right >> 23) & 1 ? v_high : v_low) : v_low, 0, trise);
	V(in1[24]) <+ transition(($abstime >= 11n + T_dur && $abstime < 11n + Twrite_dur) ?
                    ((row11_value_left >> 24) & 1 ? v_high : v_low) : v_low, 0, trise);
	V(in2[24]) <+ transition(($abstime >= 11n + T_dur && $abstime < 11n + Twrite_dur) ?
                    ((row11_value_right >> 24) & 1 ? v_high : v_low) : v_low, 0, trise);
	V(in1[25]) <+ transition(($abstime >= 11n + T_dur && $abstime < 11n + Twrite_dur) ?
                    ((row11_value_left >> 25) & 1 ? v_high : v_low) : v_low, 0, trise);
	V(in2[25]) <+ transition(($abstime >= 11n + T_dur && $abstime < 11n + Twrite_dur) ?
                    ((row11_value_right >> 25) & 1 ? v_high : v_low) : v_low, 0, trise);
	V(in1[26]) <+ transition(($abstime >= 11n + T_dur && $abstime < 11n + Twrite_dur) ?
                    ((row11_value_left >> 26) & 1 ? v_high : v_low) : v_low, 0, trise);
	V(in2[26]) <+ transition(($abstime >= 11n + T_dur && $abstime < 11n + Twrite_dur) ?
                    ((row11_value_right >> 26) & 1 ? v_high : v_low) : v_low, 0, trise);
	V(in1[27]) <+ transition(($abstime >= 11n + T_dur && $abstime < 11n + Twrite_dur) ?
                    ((row11_value_left >> 27) & 1 ? v_high : v_low) : v_low, 0, trise);
	V(in2[27]) <+ transition(($abstime >= 11n + T_dur && $abstime < 11n + Twrite_dur) ?
                    ((row11_value_right >> 27) & 1 ? v_high : v_low) : v_low, 0, trise);
	V(in1[28]) <+ transition(($abstime >= 11n + T_dur && $abstime < 11n + Twrite_dur) ?
                    ((row11_value_left >> 28) & 1 ? v_high : v_low) : v_low, 0, trise);
	V(in2[28]) <+ transition(($abstime >= 11n + T_dur && $abstime < 11n + Twrite_dur) ?
                    ((row11_value_right >> 28) & 1 ? v_high : v_low) : v_low, 0, trise);
	V(in1[29]) <+ transition(($abstime >= 11n + T_dur && $abstime < 11n + Twrite_dur) ?
                    ((row11_value_left >> 29) & 1 ? v_high : v_low) : v_low, 0, trise);
	V(in2[29]) <+ transition(($abstime >= 11n + T_dur && $abstime < 11n + Twrite_dur) ?
                    ((row11_value_right >> 29) & 1 ? v_high : v_low) : v_low, 0, trise);
	V(in1[30]) <+ transition(($abstime >= 11n + T_dur && $abstime < 11n + Twrite_dur) ?
                    ((row11_value_left >> 30) & 1 ? v_high : v_low) : v_low, 0, trise);
	V(in2[30]) <+ transition(($abstime >= 11n + T_dur && $abstime < 11n + Twrite_dur) ?
                    ((row11_value_right >> 30) & 1 ? v_high : v_low) : v_low, 0, trise);
	V(in1[31]) <+ transition(($abstime >= 11n + T_dur && $abstime < 11n + Twrite_dur) ?
                    ((row11_value_left >> 31) & 1 ? v_high : v_low) : v_low, 0, trise);
	V(in2[31]) <+ transition(($abstime >= 11n + T_dur && $abstime < 11n + Twrite_dur) ?
                    ((row11_value_right >> 31) & 1 ? v_high : v_low) : v_low, 0, trise);

    V(write) <+ transition(($abstime >= 12n + T_dur && $abstime < 12n + Twrite_dur) ? v_high : v_low, 0, trise);
    V(WL[12]) <+ transition(($abstime >= 12n + T_dur && $abstime < 12n + TWL_dur) ? v_high : v_low, 0, trise);
	V(in1[0]) <+ transition(($abstime >= 12n + T_dur && $abstime < 12n + Twrite_dur) ?
                    ((row12_value_left >> 0) & 1 ? v_high : v_low) : v_low, 0, trise);
	V(in2[0]) <+ transition(($abstime >= 12n + T_dur && $abstime < 12n + Twrite_dur) ?
                    ((row12_value_right >> 0) & 1 ? v_high : v_low) : v_low, 0, trise);
	V(in1[1]) <+ transition(($abstime >= 12n + T_dur && $abstime < 12n + Twrite_dur) ?
                    ((row12_value_left >> 1) & 1 ? v_high : v_low) : v_low, 0, trise);
	V(in2[1]) <+ transition(($abstime >= 12n + T_dur && $abstime < 12n + Twrite_dur) ?
                    ((row12_value_right >> 1) & 1 ? v_high : v_low) : v_low, 0, trise);
	V(in1[2]) <+ transition(($abstime >= 12n + T_dur && $abstime < 12n + Twrite_dur) ?
                    ((row12_value_left >> 2) & 1 ? v_high : v_low) : v_low, 0, trise);
	V(in2[2]) <+ transition(($abstime >= 12n + T_dur && $abstime < 12n + Twrite_dur) ?
                    ((row12_value_right >> 2) & 1 ? v_high : v_low) : v_low, 0, trise);
	V(in1[3]) <+ transition(($abstime >= 12n + T_dur && $abstime < 12n + Twrite_dur) ?
                    ((row12_value_left >> 3) & 1 ? v_high : v_low) : v_low, 0, trise);
	V(in2[3]) <+ transition(($abstime >= 12n + T_dur && $abstime < 12n + Twrite_dur) ?
                    ((row12_value_right >> 3) & 1 ? v_high : v_low) : v_low, 0, trise);
	V(in1[4]) <+ transition(($abstime >= 12n + T_dur && $abstime < 12n + Twrite_dur) ?
                    ((row12_value_left >> 4) & 1 ? v_high : v_low) : v_low, 0, trise);
	V(in2[4]) <+ transition(($abstime >= 12n + T_dur && $abstime < 12n + Twrite_dur) ?
                    ((row12_value_right >> 4) & 1 ? v_high : v_low) : v_low, 0, trise);
	V(in1[5]) <+ transition(($abstime >= 12n + T_dur && $abstime < 12n + Twrite_dur) ?
                    ((row12_value_left >> 5) & 1 ? v_high : v_low) : v_low, 0, trise);
	V(in2[5]) <+ transition(($abstime >= 12n + T_dur && $abstime < 12n + Twrite_dur) ?
                    ((row12_value_right >> 5) & 1 ? v_high : v_low) : v_low, 0, trise);
	V(in1[6]) <+ transition(($abstime >= 12n + T_dur && $abstime < 12n + Twrite_dur) ?
                    ((row12_value_left >> 6) & 1 ? v_high : v_low) : v_low, 0, trise);
	V(in2[6]) <+ transition(($abstime >= 12n + T_dur && $abstime < 12n + Twrite_dur) ?
                    ((row12_value_right >> 6) & 1 ? v_high : v_low) : v_low, 0, trise);
	V(in1[7]) <+ transition(($abstime >= 12n + T_dur && $abstime < 12n + Twrite_dur) ?
                    ((row12_value_left >> 7) & 1 ? v_high : v_low) : v_low, 0, trise);
	V(in2[7]) <+ transition(($abstime >= 12n + T_dur && $abstime < 12n + Twrite_dur) ?
                    ((row12_value_right >> 7) & 1 ? v_high : v_low) : v_low, 0, trise);
	V(in1[8]) <+ transition(($abstime >= 12n + T_dur && $abstime < 12n + Twrite_dur) ?
                    ((row12_value_left >> 8) & 1 ? v_high : v_low) : v_low, 0, trise);
	V(in2[8]) <+ transition(($abstime >= 12n + T_dur && $abstime < 12n + Twrite_dur) ?
                    ((row12_value_right >> 8) & 1 ? v_high : v_low) : v_low, 0, trise);
	V(in1[9]) <+ transition(($abstime >= 12n + T_dur && $abstime < 12n + Twrite_dur) ?
                    ((row12_value_left >> 9) & 1 ? v_high : v_low) : v_low, 0, trise);
	V(in2[9]) <+ transition(($abstime >= 12n + T_dur && $abstime < 12n + Twrite_dur) ?
                    ((row12_value_right >> 9) & 1 ? v_high : v_low) : v_low, 0, trise);
	V(in1[10]) <+ transition(($abstime >= 12n + T_dur && $abstime < 12n + Twrite_dur) ?
                    ((row12_value_left >> 10) & 1 ? v_high : v_low) : v_low, 0, trise);
	V(in2[10]) <+ transition(($abstime >= 12n + T_dur && $abstime < 12n + Twrite_dur) ?
                    ((row12_value_right >> 10) & 1 ? v_high : v_low) : v_low, 0, trise);
	V(in1[11]) <+ transition(($abstime >= 12n + T_dur && $abstime < 12n + Twrite_dur) ?
                    ((row12_value_left >> 11) & 1 ? v_high : v_low) : v_low, 0, trise);
	V(in2[11]) <+ transition(($abstime >= 12n + T_dur && $abstime < 12n + Twrite_dur) ?
                    ((row12_value_right >> 11) & 1 ? v_high : v_low) : v_low, 0, trise);
	V(in1[12]) <+ transition(($abstime >= 12n + T_dur && $abstime < 12n + Twrite_dur) ?
                    ((row12_value_left >> 12) & 1 ? v_high : v_low) : v_low, 0, trise);
	V(in2[12]) <+ transition(($abstime >= 12n + T_dur && $abstime < 12n + Twrite_dur) ?
                    ((row12_value_right >> 12) & 1 ? v_high : v_low) : v_low, 0, trise);
	V(in1[13]) <+ transition(($abstime >= 12n + T_dur && $abstime < 12n + Twrite_dur) ?
                    ((row12_value_left >> 13) & 1 ? v_high : v_low) : v_low, 0, trise);
	V(in2[13]) <+ transition(($abstime >= 12n + T_dur && $abstime < 12n + Twrite_dur) ?
                    ((row12_value_right >> 13) & 1 ? v_high : v_low) : v_low, 0, trise);
	V(in1[14]) <+ transition(($abstime >= 12n + T_dur && $abstime < 12n + Twrite_dur) ?
                    ((row12_value_left >> 14) & 1 ? v_high : v_low) : v_low, 0, trise);
	V(in2[14]) <+ transition(($abstime >= 12n + T_dur && $abstime < 12n + Twrite_dur) ?
                    ((row12_value_right >> 14) & 1 ? v_high : v_low) : v_low, 0, trise);
	V(in1[15]) <+ transition(($abstime >= 12n + T_dur && $abstime < 12n + Twrite_dur) ?
                    ((row12_value_left >> 15) & 1 ? v_high : v_low) : v_low, 0, trise);
	V(in2[15]) <+ transition(($abstime >= 12n + T_dur && $abstime < 12n + Twrite_dur) ?
                    ((row12_value_right >> 15) & 1 ? v_high : v_low) : v_low, 0, trise);
	V(in1[16]) <+ transition(($abstime >= 12n + T_dur && $abstime < 12n + Twrite_dur) ?
                    ((row12_value_left >> 16) & 1 ? v_high : v_low) : v_low, 0, trise);
	V(in2[16]) <+ transition(($abstime >= 12n + T_dur && $abstime < 12n + Twrite_dur) ?
                    ((row12_value_right >> 16) & 1 ? v_high : v_low) : v_low, 0, trise);
	V(in1[17]) <+ transition(($abstime >= 12n + T_dur && $abstime < 12n + Twrite_dur) ?
                    ((row12_value_left >> 17) & 1 ? v_high : v_low) : v_low, 0, trise);
	V(in2[17]) <+ transition(($abstime >= 12n + T_dur && $abstime < 12n + Twrite_dur) ?
                    ((row12_value_right >> 17) & 1 ? v_high : v_low) : v_low, 0, trise);
	V(in1[18]) <+ transition(($abstime >= 12n + T_dur && $abstime < 12n + Twrite_dur) ?
                    ((row12_value_left >> 18) & 1 ? v_high : v_low) : v_low, 0, trise);
	V(in2[18]) <+ transition(($abstime >= 12n + T_dur && $abstime < 12n + Twrite_dur) ?
                    ((row12_value_right >> 18) & 1 ? v_high : v_low) : v_low, 0, trise);
	V(in1[19]) <+ transition(($abstime >= 12n + T_dur && $abstime < 12n + Twrite_dur) ?
                    ((row12_value_left >> 19) & 1 ? v_high : v_low) : v_low, 0, trise);
	V(in2[19]) <+ transition(($abstime >= 12n + T_dur && $abstime < 12n + Twrite_dur) ?
                    ((row12_value_right >> 19) & 1 ? v_high : v_low) : v_low, 0, trise);
	V(in1[20]) <+ transition(($abstime >= 12n + T_dur && $abstime < 12n + Twrite_dur) ?
                    ((row12_value_left >> 20) & 1 ? v_high : v_low) : v_low, 0, trise);
	V(in2[20]) <+ transition(($abstime >= 12n + T_dur && $abstime < 12n + Twrite_dur) ?
                    ((row12_value_right >> 20) & 1 ? v_high : v_low) : v_low, 0, trise);
	V(in1[21]) <+ transition(($abstime >= 12n + T_dur && $abstime < 12n + Twrite_dur) ?
                    ((row12_value_left >> 21) & 1 ? v_high : v_low) : v_low, 0, trise);
	V(in2[21]) <+ transition(($abstime >= 12n + T_dur && $abstime < 12n + Twrite_dur) ?
                    ((row12_value_right >> 21) & 1 ? v_high : v_low) : v_low, 0, trise);
	V(in1[22]) <+ transition(($abstime >= 12n + T_dur && $abstime < 12n + Twrite_dur) ?
                    ((row12_value_left >> 22) & 1 ? v_high : v_low) : v_low, 0, trise);
	V(in2[22]) <+ transition(($abstime >= 12n + T_dur && $abstime < 12n + Twrite_dur) ?
                    ((row12_value_right >> 22) & 1 ? v_high : v_low) : v_low, 0, trise);
	V(in1[23]) <+ transition(($abstime >= 12n + T_dur && $abstime < 12n + Twrite_dur) ?
                    ((row12_value_left >> 23) & 1 ? v_high : v_low) : v_low, 0, trise);
	V(in2[23]) <+ transition(($abstime >= 12n + T_dur && $abstime < 12n + Twrite_dur) ?
                    ((row12_value_right >> 23) & 1 ? v_high : v_low) : v_low, 0, trise);
	V(in1[24]) <+ transition(($abstime >= 12n + T_dur && $abstime < 12n + Twrite_dur) ?
                    ((row12_value_left >> 24) & 1 ? v_high : v_low) : v_low, 0, trise);
	V(in2[24]) <+ transition(($abstime >= 12n + T_dur && $abstime < 12n + Twrite_dur) ?
                    ((row12_value_right >> 24) & 1 ? v_high : v_low) : v_low, 0, trise);
	V(in1[25]) <+ transition(($abstime >= 12n + T_dur && $abstime < 12n + Twrite_dur) ?
                    ((row12_value_left >> 25) & 1 ? v_high : v_low) : v_low, 0, trise);
	V(in2[25]) <+ transition(($abstime >= 12n + T_dur && $abstime < 12n + Twrite_dur) ?
                    ((row12_value_right >> 25) & 1 ? v_high : v_low) : v_low, 0, trise);
	V(in1[26]) <+ transition(($abstime >= 12n + T_dur && $abstime < 12n + Twrite_dur) ?
                    ((row12_value_left >> 26) & 1 ? v_high : v_low) : v_low, 0, trise);
	V(in2[26]) <+ transition(($abstime >= 12n + T_dur && $abstime < 12n + Twrite_dur) ?
                    ((row12_value_right >> 26) & 1 ? v_high : v_low) : v_low, 0, trise);
	V(in1[27]) <+ transition(($abstime >= 12n + T_dur && $abstime < 12n + Twrite_dur) ?
                    ((row12_value_left >> 27) & 1 ? v_high : v_low) : v_low, 0, trise);
	V(in2[27]) <+ transition(($abstime >= 12n + T_dur && $abstime < 12n + Twrite_dur) ?
                    ((row12_value_right >> 27) & 1 ? v_high : v_low) : v_low, 0, trise);
	V(in1[28]) <+ transition(($abstime >= 12n + T_dur && $abstime < 12n + Twrite_dur) ?
                    ((row12_value_left >> 28) & 1 ? v_high : v_low) : v_low, 0, trise);
	V(in2[28]) <+ transition(($abstime >= 12n + T_dur && $abstime < 12n + Twrite_dur) ?
                    ((row12_value_right >> 28) & 1 ? v_high : v_low) : v_low, 0, trise);
	V(in1[29]) <+ transition(($abstime >= 12n + T_dur && $abstime < 12n + Twrite_dur) ?
                    ((row12_value_left >> 29) & 1 ? v_high : v_low) : v_low, 0, trise);
	V(in2[29]) <+ transition(($abstime >= 12n + T_dur && $abstime < 12n + Twrite_dur) ?
                    ((row12_value_right >> 29) & 1 ? v_high : v_low) : v_low, 0, trise);
	V(in1[30]) <+ transition(($abstime >= 12n + T_dur && $abstime < 12n + Twrite_dur) ?
                    ((row12_value_left >> 30) & 1 ? v_high : v_low) : v_low, 0, trise);
	V(in2[30]) <+ transition(($abstime >= 12n + T_dur && $abstime < 12n + Twrite_dur) ?
                    ((row12_value_right >> 30) & 1 ? v_high : v_low) : v_low, 0, trise);
	V(in1[31]) <+ transition(($abstime >= 12n + T_dur && $abstime < 12n + Twrite_dur) ?
                    ((row12_value_left >> 31) & 1 ? v_high : v_low) : v_low, 0, trise);
	V(in2[31]) <+ transition(($abstime >= 12n + T_dur && $abstime < 12n + Twrite_dur) ?
                    ((row12_value_right >> 31) & 1 ? v_high : v_low) : v_low, 0, trise);

    V(write) <+ transition(($abstime >= 13n + T_dur && $abstime < 13n + Twrite_dur) ? v_high : v_low, 0, trise);
    V(WL[13]) <+ transition(($abstime >= 13n + T_dur && $abstime < 13n + TWL_dur) ? v_high : v_low, 0, trise);
	V(in1[0]) <+ transition(($abstime >= 13n + T_dur && $abstime < 13n + Twrite_dur) ?
                    ((row13_value_left >> 0) & 1 ? v_high : v_low) : v_low, 0, trise);
	V(in2[0]) <+ transition(($abstime >= 13n + T_dur && $abstime < 13n + Twrite_dur) ?
                    ((row13_value_right >> 0) & 1 ? v_high : v_low) : v_low, 0, trise);
	V(in1[1]) <+ transition(($abstime >= 13n + T_dur && $abstime < 13n + Twrite_dur) ?
                    ((row13_value_left >> 1) & 1 ? v_high : v_low) : v_low, 0, trise);
	V(in2[1]) <+ transition(($abstime >= 13n + T_dur && $abstime < 13n + Twrite_dur) ?
                    ((row13_value_right >> 1) & 1 ? v_high : v_low) : v_low, 0, trise);
	V(in1[2]) <+ transition(($abstime >= 13n + T_dur && $abstime < 13n + Twrite_dur) ?
                    ((row13_value_left >> 2) & 1 ? v_high : v_low) : v_low, 0, trise);
	V(in2[2]) <+ transition(($abstime >= 13n + T_dur && $abstime < 13n + Twrite_dur) ?
                    ((row13_value_right >> 2) & 1 ? v_high : v_low) : v_low, 0, trise);
	V(in1[3]) <+ transition(($abstime >= 13n + T_dur && $abstime < 13n + Twrite_dur) ?
                    ((row13_value_left >> 3) & 1 ? v_high : v_low) : v_low, 0, trise);
	V(in2[3]) <+ transition(($abstime >= 13n + T_dur && $abstime < 13n + Twrite_dur) ?
                    ((row13_value_right >> 3) & 1 ? v_high : v_low) : v_low, 0, trise);
	V(in1[4]) <+ transition(($abstime >= 13n + T_dur && $abstime < 13n + Twrite_dur) ?
                    ((row13_value_left >> 4) & 1 ? v_high : v_low) : v_low, 0, trise);
	V(in2[4]) <+ transition(($abstime >= 13n + T_dur && $abstime < 13n + Twrite_dur) ?
                    ((row13_value_right >> 4) & 1 ? v_high : v_low) : v_low, 0, trise);
	V(in1[5]) <+ transition(($abstime >= 13n + T_dur && $abstime < 13n + Twrite_dur) ?
                    ((row13_value_left >> 5) & 1 ? v_high : v_low) : v_low, 0, trise);
	V(in2[5]) <+ transition(($abstime >= 13n + T_dur && $abstime < 13n + Twrite_dur) ?
                    ((row13_value_right >> 5) & 1 ? v_high : v_low) : v_low, 0, trise);
	V(in1[6]) <+ transition(($abstime >= 13n + T_dur && $abstime < 13n + Twrite_dur) ?
                    ((row13_value_left >> 6) & 1 ? v_high : v_low) : v_low, 0, trise);
	V(in2[6]) <+ transition(($abstime >= 13n + T_dur && $abstime < 13n + Twrite_dur) ?
                    ((row13_value_right >> 6) & 1 ? v_high : v_low) : v_low, 0, trise);
	V(in1[7]) <+ transition(($abstime >= 13n + T_dur && $abstime < 13n + Twrite_dur) ?
                    ((row13_value_left >> 7) & 1 ? v_high : v_low) : v_low, 0, trise);
	V(in2[7]) <+ transition(($abstime >= 13n + T_dur && $abstime < 13n + Twrite_dur) ?
                    ((row13_value_right >> 7) & 1 ? v_high : v_low) : v_low, 0, trise);
	V(in1[8]) <+ transition(($abstime >= 13n + T_dur && $abstime < 13n + Twrite_dur) ?
                    ((row13_value_left >> 8) & 1 ? v_high : v_low) : v_low, 0, trise);
	V(in2[8]) <+ transition(($abstime >= 13n + T_dur && $abstime < 13n + Twrite_dur) ?
                    ((row13_value_right >> 8) & 1 ? v_high : v_low) : v_low, 0, trise);
	V(in1[9]) <+ transition(($abstime >= 13n + T_dur && $abstime < 13n + Twrite_dur) ?
                    ((row13_value_left >> 9) & 1 ? v_high : v_low) : v_low, 0, trise);
	V(in2[9]) <+ transition(($abstime >= 13n + T_dur && $abstime < 13n + Twrite_dur) ?
                    ((row13_value_right >> 9) & 1 ? v_high : v_low) : v_low, 0, trise);
	V(in1[10]) <+ transition(($abstime >= 13n + T_dur && $abstime < 13n + Twrite_dur) ?
                    ((row13_value_left >> 10) & 1 ? v_high : v_low) : v_low, 0, trise);
	V(in2[10]) <+ transition(($abstime >= 13n + T_dur && $abstime < 13n + Twrite_dur) ?
                    ((row13_value_right >> 10) & 1 ? v_high : v_low) : v_low, 0, trise);
	V(in1[11]) <+ transition(($abstime >= 13n + T_dur && $abstime < 13n + Twrite_dur) ?
                    ((row13_value_left >> 11) & 1 ? v_high : v_low) : v_low, 0, trise);
	V(in2[11]) <+ transition(($abstime >= 13n + T_dur && $abstime < 13n + Twrite_dur) ?
                    ((row13_value_right >> 11) & 1 ? v_high : v_low) : v_low, 0, trise);
	V(in1[12]) <+ transition(($abstime >= 13n + T_dur && $abstime < 13n + Twrite_dur) ?
                    ((row13_value_left >> 12) & 1 ? v_high : v_low) : v_low, 0, trise);
	V(in2[12]) <+ transition(($abstime >= 13n + T_dur && $abstime < 13n + Twrite_dur) ?
                    ((row13_value_right >> 12) & 1 ? v_high : v_low) : v_low, 0, trise);
	V(in1[13]) <+ transition(($abstime >= 13n + T_dur && $abstime < 13n + Twrite_dur) ?
                    ((row13_value_left >> 13) & 1 ? v_high : v_low) : v_low, 0, trise);
	V(in2[13]) <+ transition(($abstime >= 13n + T_dur && $abstime < 13n + Twrite_dur) ?
                    ((row13_value_right >> 13) & 1 ? v_high : v_low) : v_low, 0, trise);
	V(in1[14]) <+ transition(($abstime >= 13n + T_dur && $abstime < 13n + Twrite_dur) ?
                    ((row13_value_left >> 14) & 1 ? v_high : v_low) : v_low, 0, trise);
	V(in2[14]) <+ transition(($abstime >= 13n + T_dur && $abstime < 13n + Twrite_dur) ?
                    ((row13_value_right >> 14) & 1 ? v_high : v_low) : v_low, 0, trise);
	V(in1[15]) <+ transition(($abstime >= 13n + T_dur && $abstime < 13n + Twrite_dur) ?
                    ((row13_value_left >> 15) & 1 ? v_high : v_low) : v_low, 0, trise);
	V(in2[15]) <+ transition(($abstime >= 13n + T_dur && $abstime < 13n + Twrite_dur) ?
                    ((row13_value_right >> 15) & 1 ? v_high : v_low) : v_low, 0, trise);
	V(in1[16]) <+ transition(($abstime >= 13n + T_dur && $abstime < 13n + Twrite_dur) ?
                    ((row13_value_left >> 16) & 1 ? v_high : v_low) : v_low, 0, trise);
	V(in2[16]) <+ transition(($abstime >= 13n + T_dur && $abstime < 13n + Twrite_dur) ?
                    ((row13_value_right >> 16) & 1 ? v_high : v_low) : v_low, 0, trise);
	V(in1[17]) <+ transition(($abstime >= 13n + T_dur && $abstime < 13n + Twrite_dur) ?
                    ((row13_value_left >> 17) & 1 ? v_high : v_low) : v_low, 0, trise);
	V(in2[17]) <+ transition(($abstime >= 13n + T_dur && $abstime < 13n + Twrite_dur) ?
                    ((row13_value_right >> 17) & 1 ? v_high : v_low) : v_low, 0, trise);
	V(in1[18]) <+ transition(($abstime >= 13n + T_dur && $abstime < 13n + Twrite_dur) ?
                    ((row13_value_left >> 18) & 1 ? v_high : v_low) : v_low, 0, trise);
	V(in2[18]) <+ transition(($abstime >= 13n + T_dur && $abstime < 13n + Twrite_dur) ?
                    ((row13_value_right >> 18) & 1 ? v_high : v_low) : v_low, 0, trise);
	V(in1[19]) <+ transition(($abstime >= 13n + T_dur && $abstime < 13n + Twrite_dur) ?
                    ((row13_value_left >> 19) & 1 ? v_high : v_low) : v_low, 0, trise);
	V(in2[19]) <+ transition(($abstime >= 13n + T_dur && $abstime < 13n + Twrite_dur) ?
                    ((row13_value_right >> 19) & 1 ? v_high : v_low) : v_low, 0, trise);
	V(in1[20]) <+ transition(($abstime >= 13n + T_dur && $abstime < 13n + Twrite_dur) ?
                    ((row13_value_left >> 20) & 1 ? v_high : v_low) : v_low, 0, trise);
	V(in2[20]) <+ transition(($abstime >= 13n + T_dur && $abstime < 13n + Twrite_dur) ?
                    ((row13_value_right >> 20) & 1 ? v_high : v_low) : v_low, 0, trise);
	V(in1[21]) <+ transition(($abstime >= 13n + T_dur && $abstime < 13n + Twrite_dur) ?
                    ((row13_value_left >> 21) & 1 ? v_high : v_low) : v_low, 0, trise);
	V(in2[21]) <+ transition(($abstime >= 13n + T_dur && $abstime < 13n + Twrite_dur) ?
                    ((row13_value_right >> 21) & 1 ? v_high : v_low) : v_low, 0, trise);
	V(in1[22]) <+ transition(($abstime >= 13n + T_dur && $abstime < 13n + Twrite_dur) ?
                    ((row13_value_left >> 22) & 1 ? v_high : v_low) : v_low, 0, trise);
	V(in2[22]) <+ transition(($abstime >= 13n + T_dur && $abstime < 13n + Twrite_dur) ?
                    ((row13_value_right >> 22) & 1 ? v_high : v_low) : v_low, 0, trise);
	V(in1[23]) <+ transition(($abstime >= 13n + T_dur && $abstime < 13n + Twrite_dur) ?
                    ((row13_value_left >> 23) & 1 ? v_high : v_low) : v_low, 0, trise);
	V(in2[23]) <+ transition(($abstime >= 13n + T_dur && $abstime < 13n + Twrite_dur) ?
                    ((row13_value_right >> 23) & 1 ? v_high : v_low) : v_low, 0, trise);
	V(in1[24]) <+ transition(($abstime >= 13n + T_dur && $abstime < 13n + Twrite_dur) ?
                    ((row13_value_left >> 24) & 1 ? v_high : v_low) : v_low, 0, trise);
	V(in2[24]) <+ transition(($abstime >= 13n + T_dur && $abstime < 13n + Twrite_dur) ?
                    ((row13_value_right >> 24) & 1 ? v_high : v_low) : v_low, 0, trise);
	V(in1[25]) <+ transition(($abstime >= 13n + T_dur && $abstime < 13n + Twrite_dur) ?
                    ((row13_value_left >> 25) & 1 ? v_high : v_low) : v_low, 0, trise);
	V(in2[25]) <+ transition(($abstime >= 13n + T_dur && $abstime < 13n + Twrite_dur) ?
                    ((row13_value_right >> 25) & 1 ? v_high : v_low) : v_low, 0, trise);
	V(in1[26]) <+ transition(($abstime >= 13n + T_dur && $abstime < 13n + Twrite_dur) ?
                    ((row13_value_left >> 26) & 1 ? v_high : v_low) : v_low, 0, trise);
	V(in2[26]) <+ transition(($abstime >= 13n + T_dur && $abstime < 13n + Twrite_dur) ?
                    ((row13_value_right >> 26) & 1 ? v_high : v_low) : v_low, 0, trise);
	V(in1[27]) <+ transition(($abstime >= 13n + T_dur && $abstime < 13n + Twrite_dur) ?
                    ((row13_value_left >> 27) & 1 ? v_high : v_low) : v_low, 0, trise);
	V(in2[27]) <+ transition(($abstime >= 13n + T_dur && $abstime < 13n + Twrite_dur) ?
                    ((row13_value_right >> 27) & 1 ? v_high : v_low) : v_low, 0, trise);
	V(in1[28]) <+ transition(($abstime >= 13n + T_dur && $abstime < 13n + Twrite_dur) ?
                    ((row13_value_left >> 28) & 1 ? v_high : v_low) : v_low, 0, trise);
	V(in2[28]) <+ transition(($abstime >= 13n + T_dur && $abstime < 13n + Twrite_dur) ?
                    ((row13_value_right >> 28) & 1 ? v_high : v_low) : v_low, 0, trise);
	V(in1[29]) <+ transition(($abstime >= 13n + T_dur && $abstime < 13n + Twrite_dur) ?
                    ((row13_value_left >> 29) & 1 ? v_high : v_low) : v_low, 0, trise);
	V(in2[29]) <+ transition(($abstime >= 13n + T_dur && $abstime < 13n + Twrite_dur) ?
                    ((row13_value_right >> 29) & 1 ? v_high : v_low) : v_low, 0, trise);
	V(in1[30]) <+ transition(($abstime >= 13n + T_dur && $abstime < 13n + Twrite_dur) ?
                    ((row13_value_left >> 30) & 1 ? v_high : v_low) : v_low, 0, trise);
	V(in2[30]) <+ transition(($abstime >= 13n + T_dur && $abstime < 13n + Twrite_dur) ?
                    ((row13_value_right >> 30) & 1 ? v_high : v_low) : v_low, 0, trise);
	V(in1[31]) <+ transition(($abstime >= 13n + T_dur && $abstime < 13n + Twrite_dur) ?
                    ((row13_value_left >> 31) & 1 ? v_high : v_low) : v_low, 0, trise);
	V(in2[31]) <+ transition(($abstime >= 13n + T_dur && $abstime < 13n + Twrite_dur) ?
                    ((row13_value_right >> 31) & 1 ? v_high : v_low) : v_low, 0, trise);

    V(write) <+ transition(($abstime >= 14n + T_dur && $abstime < 14n + Twrite_dur) ? v_high : v_low, 0, trise);
    V(WL[14]) <+ transition(($abstime >= 14n + T_dur && $abstime < 14n + TWL_dur) ? v_high : v_low, 0, trise);
	V(in1[0]) <+ transition(($abstime >= 14n + T_dur && $abstime < 14n + Twrite_dur) ?
                    ((row14_value_left >> 0) & 1 ? v_high : v_low) : v_low, 0, trise);
	V(in2[0]) <+ transition(($abstime >= 14n + T_dur && $abstime < 14n + Twrite_dur) ?
                    ((row14_value_right >> 0) & 1 ? v_high : v_low) : v_low, 0, trise);
	V(in1[1]) <+ transition(($abstime >= 14n + T_dur && $abstime < 14n + Twrite_dur) ?
                    ((row14_value_left >> 1) & 1 ? v_high : v_low) : v_low, 0, trise);
	V(in2[1]) <+ transition(($abstime >= 14n + T_dur && $abstime < 14n + Twrite_dur) ?
                    ((row14_value_right >> 1) & 1 ? v_high : v_low) : v_low, 0, trise);
	V(in1[2]) <+ transition(($abstime >= 14n + T_dur && $abstime < 14n + Twrite_dur) ?
                    ((row14_value_left >> 2) & 1 ? v_high : v_low) : v_low, 0, trise);
	V(in2[2]) <+ transition(($abstime >= 14n + T_dur && $abstime < 14n + Twrite_dur) ?
                    ((row14_value_right >> 2) & 1 ? v_high : v_low) : v_low, 0, trise);
	V(in1[3]) <+ transition(($abstime >= 14n + T_dur && $abstime < 14n + Twrite_dur) ?
                    ((row14_value_left >> 3) & 1 ? v_high : v_low) : v_low, 0, trise);
	V(in2[3]) <+ transition(($abstime >= 14n + T_dur && $abstime < 14n + Twrite_dur) ?
                    ((row14_value_right >> 3) & 1 ? v_high : v_low) : v_low, 0, trise);
	V(in1[4]) <+ transition(($abstime >= 14n + T_dur && $abstime < 14n + Twrite_dur) ?
                    ((row14_value_left >> 4) & 1 ? v_high : v_low) : v_low, 0, trise);
	V(in2[4]) <+ transition(($abstime >= 14n + T_dur && $abstime < 14n + Twrite_dur) ?
                    ((row14_value_right >> 4) & 1 ? v_high : v_low) : v_low, 0, trise);
	V(in1[5]) <+ transition(($abstime >= 14n + T_dur && $abstime < 14n + Twrite_dur) ?
                    ((row14_value_left >> 5) & 1 ? v_high : v_low) : v_low, 0, trise);
	V(in2[5]) <+ transition(($abstime >= 14n + T_dur && $abstime < 14n + Twrite_dur) ?
                    ((row14_value_right >> 5) & 1 ? v_high : v_low) : v_low, 0, trise);
	V(in1[6]) <+ transition(($abstime >= 14n + T_dur && $abstime < 14n + Twrite_dur) ?
                    ((row14_value_left >> 6) & 1 ? v_high : v_low) : v_low, 0, trise);
	V(in2[6]) <+ transition(($abstime >= 14n + T_dur && $abstime < 14n + Twrite_dur) ?
                    ((row14_value_right >> 6) & 1 ? v_high : v_low) : v_low, 0, trise);
	V(in1[7]) <+ transition(($abstime >= 14n + T_dur && $abstime < 14n + Twrite_dur) ?
                    ((row14_value_left >> 7) & 1 ? v_high : v_low) : v_low, 0, trise);
	V(in2[7]) <+ transition(($abstime >= 14n + T_dur && $abstime < 14n + Twrite_dur) ?
                    ((row14_value_right >> 7) & 1 ? v_high : v_low) : v_low, 0, trise);
	V(in1[8]) <+ transition(($abstime >= 14n + T_dur && $abstime < 14n + Twrite_dur) ?
                    ((row14_value_left >> 8) & 1 ? v_high : v_low) : v_low, 0, trise);
	V(in2[8]) <+ transition(($abstime >= 14n + T_dur && $abstime < 14n + Twrite_dur) ?
                    ((row14_value_right >> 8) & 1 ? v_high : v_low) : v_low, 0, trise);
	V(in1[9]) <+ transition(($abstime >= 14n + T_dur && $abstime < 14n + Twrite_dur) ?
                    ((row14_value_left >> 9) & 1 ? v_high : v_low) : v_low, 0, trise);
	V(in2[9]) <+ transition(($abstime >= 14n + T_dur && $abstime < 14n + Twrite_dur) ?
                    ((row14_value_right >> 9) & 1 ? v_high : v_low) : v_low, 0, trise);
	V(in1[10]) <+ transition(($abstime >= 14n + T_dur && $abstime < 14n + Twrite_dur) ?
                    ((row14_value_left >> 10) & 1 ? v_high : v_low) : v_low, 0, trise);
	V(in2[10]) <+ transition(($abstime >= 14n + T_dur && $abstime < 14n + Twrite_dur) ?
                    ((row14_value_right >> 10) & 1 ? v_high : v_low) : v_low, 0, trise);
	V(in1[11]) <+ transition(($abstime >= 14n + T_dur && $abstime < 14n + Twrite_dur) ?
                    ((row14_value_left >> 11) & 1 ? v_high : v_low) : v_low, 0, trise);
	V(in2[11]) <+ transition(($abstime >= 14n + T_dur && $abstime < 14n + Twrite_dur) ?
                    ((row14_value_right >> 11) & 1 ? v_high : v_low) : v_low, 0, trise);
	V(in1[12]) <+ transition(($abstime >= 14n + T_dur && $abstime < 14n + Twrite_dur) ?
                    ((row14_value_left >> 12) & 1 ? v_high : v_low) : v_low, 0, trise);
	V(in2[12]) <+ transition(($abstime >= 14n + T_dur && $abstime < 14n + Twrite_dur) ?
                    ((row14_value_right >> 12) & 1 ? v_high : v_low) : v_low, 0, trise);
	V(in1[13]) <+ transition(($abstime >= 14n + T_dur && $abstime < 14n + Twrite_dur) ?
                    ((row14_value_left >> 13) & 1 ? v_high : v_low) : v_low, 0, trise);
	V(in2[13]) <+ transition(($abstime >= 14n + T_dur && $abstime < 14n + Twrite_dur) ?
                    ((row14_value_right >> 13) & 1 ? v_high : v_low) : v_low, 0, trise);
	V(in1[14]) <+ transition(($abstime >= 14n + T_dur && $abstime < 14n + Twrite_dur) ?
                    ((row14_value_left >> 14) & 1 ? v_high : v_low) : v_low, 0, trise);
	V(in2[14]) <+ transition(($abstime >= 14n + T_dur && $abstime < 14n + Twrite_dur) ?
                    ((row14_value_right >> 14) & 1 ? v_high : v_low) : v_low, 0, trise);
	V(in1[15]) <+ transition(($abstime >= 14n + T_dur && $abstime < 14n + Twrite_dur) ?
                    ((row14_value_left >> 15) & 1 ? v_high : v_low) : v_low, 0, trise);
	V(in2[15]) <+ transition(($abstime >= 14n + T_dur && $abstime < 14n + Twrite_dur) ?
                    ((row14_value_right >> 15) & 1 ? v_high : v_low) : v_low, 0, trise);
	V(in1[16]) <+ transition(($abstime >= 14n + T_dur && $abstime < 14n + Twrite_dur) ?
                    ((row14_value_left >> 16) & 1 ? v_high : v_low) : v_low, 0, trise);
	V(in2[16]) <+ transition(($abstime >= 14n + T_dur && $abstime < 14n + Twrite_dur) ?
                    ((row14_value_right >> 16) & 1 ? v_high : v_low) : v_low, 0, trise);
	V(in1[17]) <+ transition(($abstime >= 14n + T_dur && $abstime < 14n + Twrite_dur) ?
                    ((row14_value_left >> 17) & 1 ? v_high : v_low) : v_low, 0, trise);
	V(in2[17]) <+ transition(($abstime >= 14n + T_dur && $abstime < 14n + Twrite_dur) ?
                    ((row14_value_right >> 17) & 1 ? v_high : v_low) : v_low, 0, trise);
	V(in1[18]) <+ transition(($abstime >= 14n + T_dur && $abstime < 14n + Twrite_dur) ?
                    ((row14_value_left >> 18) & 1 ? v_high : v_low) : v_low, 0, trise);
	V(in2[18]) <+ transition(($abstime >= 14n + T_dur && $abstime < 14n + Twrite_dur) ?
                    ((row14_value_right >> 18) & 1 ? v_high : v_low) : v_low, 0, trise);
	V(in1[19]) <+ transition(($abstime >= 14n + T_dur && $abstime < 14n + Twrite_dur) ?
                    ((row14_value_left >> 19) & 1 ? v_high : v_low) : v_low, 0, trise);
	V(in2[19]) <+ transition(($abstime >= 14n + T_dur && $abstime < 14n + Twrite_dur) ?
                    ((row14_value_right >> 19) & 1 ? v_high : v_low) : v_low, 0, trise);
	V(in1[20]) <+ transition(($abstime >= 14n + T_dur && $abstime < 14n + Twrite_dur) ?
                    ((row14_value_left >> 20) & 1 ? v_high : v_low) : v_low, 0, trise);
	V(in2[20]) <+ transition(($abstime >= 14n + T_dur && $abstime < 14n + Twrite_dur) ?
                    ((row14_value_right >> 20) & 1 ? v_high : v_low) : v_low, 0, trise);
	V(in1[21]) <+ transition(($abstime >= 14n + T_dur && $abstime < 14n + Twrite_dur) ?
                    ((row14_value_left >> 21) & 1 ? v_high : v_low) : v_low, 0, trise);
	V(in2[21]) <+ transition(($abstime >= 14n + T_dur && $abstime < 14n + Twrite_dur) ?
                    ((row14_value_right >> 21) & 1 ? v_high : v_low) : v_low, 0, trise);
	V(in1[22]) <+ transition(($abstime >= 14n + T_dur && $abstime < 14n + Twrite_dur) ?
                    ((row14_value_left >> 22) & 1 ? v_high : v_low) : v_low, 0, trise);
	V(in2[22]) <+ transition(($abstime >= 14n + T_dur && $abstime < 14n + Twrite_dur) ?
                    ((row14_value_right >> 22) & 1 ? v_high : v_low) : v_low, 0, trise);
	V(in1[23]) <+ transition(($abstime >= 14n + T_dur && $abstime < 14n + Twrite_dur) ?
                    ((row14_value_left >> 23) & 1 ? v_high : v_low) : v_low, 0, trise);
	V(in2[23]) <+ transition(($abstime >= 14n + T_dur && $abstime < 14n + Twrite_dur) ?
                    ((row14_value_right >> 23) & 1 ? v_high : v_low) : v_low, 0, trise);
	V(in1[24]) <+ transition(($abstime >= 14n + T_dur && $abstime < 14n + Twrite_dur) ?
                    ((row14_value_left >> 24) & 1 ? v_high : v_low) : v_low, 0, trise);
	V(in2[24]) <+ transition(($abstime >= 14n + T_dur && $abstime < 14n + Twrite_dur) ?
                    ((row14_value_right >> 24) & 1 ? v_high : v_low) : v_low, 0, trise);
	V(in1[25]) <+ transition(($abstime >= 14n + T_dur && $abstime < 14n + Twrite_dur) ?
                    ((row14_value_left >> 25) & 1 ? v_high : v_low) : v_low, 0, trise);
	V(in2[25]) <+ transition(($abstime >= 14n + T_dur && $abstime < 14n + Twrite_dur) ?
                    ((row14_value_right >> 25) & 1 ? v_high : v_low) : v_low, 0, trise);
	V(in1[26]) <+ transition(($abstime >= 14n + T_dur && $abstime < 14n + Twrite_dur) ?
                    ((row14_value_left >> 26) & 1 ? v_high : v_low) : v_low, 0, trise);
	V(in2[26]) <+ transition(($abstime >= 14n + T_dur && $abstime < 14n + Twrite_dur) ?
                    ((row14_value_right >> 26) & 1 ? v_high : v_low) : v_low, 0, trise);
	V(in1[27]) <+ transition(($abstime >= 14n + T_dur && $abstime < 14n + Twrite_dur) ?
                    ((row14_value_left >> 27) & 1 ? v_high : v_low) : v_low, 0, trise);
	V(in2[27]) <+ transition(($abstime >= 14n + T_dur && $abstime < 14n + Twrite_dur) ?
                    ((row14_value_right >> 27) & 1 ? v_high : v_low) : v_low, 0, trise);
	V(in1[28]) <+ transition(($abstime >= 14n + T_dur && $abstime < 14n + Twrite_dur) ?
                    ((row14_value_left >> 28) & 1 ? v_high : v_low) : v_low, 0, trise);
	V(in2[28]) <+ transition(($abstime >= 14n + T_dur && $abstime < 14n + Twrite_dur) ?
                    ((row14_value_right >> 28) & 1 ? v_high : v_low) : v_low, 0, trise);
	V(in1[29]) <+ transition(($abstime >= 14n + T_dur && $abstime < 14n + Twrite_dur) ?
                    ((row14_value_left >> 29) & 1 ? v_high : v_low) : v_low, 0, trise);
	V(in2[29]) <+ transition(($abstime >= 14n + T_dur && $abstime < 14n + Twrite_dur) ?
                    ((row14_value_right >> 29) & 1 ? v_high : v_low) : v_low, 0, trise);
	V(in1[30]) <+ transition(($abstime >= 14n + T_dur && $abstime < 14n + Twrite_dur) ?
                    ((row14_value_left >> 30) & 1 ? v_high : v_low) : v_low, 0, trise);
	V(in2[30]) <+ transition(($abstime >= 14n + T_dur && $abstime < 14n + Twrite_dur) ?
                    ((row14_value_right >> 30) & 1 ? v_high : v_low) : v_low, 0, trise);
	V(in1[31]) <+ transition(($abstime >= 14n + T_dur && $abstime < 14n + Twrite_dur) ?
                    ((row14_value_left >> 31) & 1 ? v_high : v_low) : v_low, 0, trise);
	V(in2[31]) <+ transition(($abstime >= 14n + T_dur && $abstime < 14n + Twrite_dur) ?
                    ((row14_value_right >> 31) & 1 ? v_high : v_low) : v_low, 0, trise);

    V(write) <+ transition(($abstime >= 15n + T_dur && $abstime < 15n + Twrite_dur) ? v_high : v_low, 0, trise);
    V(WL[15]) <+ transition(($abstime >= 15n + T_dur && $abstime < 15n + TWL_dur) ? v_high : v_low, 0, trise);
	V(in1[0]) <+ transition(($abstime >= 15n + T_dur && $abstime < 15n + Twrite_dur) ?
                    ((row15_value_left >> 0) & 1 ? v_high : v_low) : v_low, 0, trise);
	V(in2[0]) <+ transition(($abstime >= 15n + T_dur && $abstime < 15n + Twrite_dur) ?
                    ((row15_value_right >> 0) & 1 ? v_high : v_low) : v_low, 0, trise);
	V(in1[1]) <+ transition(($abstime >= 15n + T_dur && $abstime < 15n + Twrite_dur) ?
                    ((row15_value_left >> 1) & 1 ? v_high : v_low) : v_low, 0, trise);
	V(in2[1]) <+ transition(($abstime >= 15n + T_dur && $abstime < 15n + Twrite_dur) ?
                    ((row15_value_right >> 1) & 1 ? v_high : v_low) : v_low, 0, trise);
	V(in1[2]) <+ transition(($abstime >= 15n + T_dur && $abstime < 15n + Twrite_dur) ?
                    ((row15_value_left >> 2) & 1 ? v_high : v_low) : v_low, 0, trise);
	V(in2[2]) <+ transition(($abstime >= 15n + T_dur && $abstime < 15n + Twrite_dur) ?
                    ((row15_value_right >> 2) & 1 ? v_high : v_low) : v_low, 0, trise);
	V(in1[3]) <+ transition(($abstime >= 15n + T_dur && $abstime < 15n + Twrite_dur) ?
                    ((row15_value_left >> 3) & 1 ? v_high : v_low) : v_low, 0, trise);
	V(in2[3]) <+ transition(($abstime >= 15n + T_dur && $abstime < 15n + Twrite_dur) ?
                    ((row15_value_right >> 3) & 1 ? v_high : v_low) : v_low, 0, trise);
	V(in1[4]) <+ transition(($abstime >= 15n + T_dur && $abstime < 15n + Twrite_dur) ?
                    ((row15_value_left >> 4) & 1 ? v_high : v_low) : v_low, 0, trise);
	V(in2[4]) <+ transition(($abstime >= 15n + T_dur && $abstime < 15n + Twrite_dur) ?
                    ((row15_value_right >> 4) & 1 ? v_high : v_low) : v_low, 0, trise);
	V(in1[5]) <+ transition(($abstime >= 15n + T_dur && $abstime < 15n + Twrite_dur) ?
                    ((row15_value_left >> 5) & 1 ? v_high : v_low) : v_low, 0, trise);
	V(in2[5]) <+ transition(($abstime >= 15n + T_dur && $abstime < 15n + Twrite_dur) ?
                    ((row15_value_right >> 5) & 1 ? v_high : v_low) : v_low, 0, trise);
	V(in1[6]) <+ transition(($abstime >= 15n + T_dur && $abstime < 15n + Twrite_dur) ?
                    ((row15_value_left >> 6) & 1 ? v_high : v_low) : v_low, 0, trise);
	V(in2[6]) <+ transition(($abstime >= 15n + T_dur && $abstime < 15n + Twrite_dur) ?
                    ((row15_value_right >> 6) & 1 ? v_high : v_low) : v_low, 0, trise);
	V(in1[7]) <+ transition(($abstime >= 15n + T_dur && $abstime < 15n + Twrite_dur) ?
                    ((row15_value_left >> 7) & 1 ? v_high : v_low) : v_low, 0, trise);
	V(in2[7]) <+ transition(($abstime >= 15n + T_dur && $abstime < 15n + Twrite_dur) ?
                    ((row15_value_right >> 7) & 1 ? v_high : v_low) : v_low, 0, trise);
	V(in1[8]) <+ transition(($abstime >= 15n + T_dur && $abstime < 15n + Twrite_dur) ?
                    ((row15_value_left >> 8) & 1 ? v_high : v_low) : v_low, 0, trise);
	V(in2[8]) <+ transition(($abstime >= 15n + T_dur && $abstime < 15n + Twrite_dur) ?
                    ((row15_value_right >> 8) & 1 ? v_high : v_low) : v_low, 0, trise);
	V(in1[9]) <+ transition(($abstime >= 15n + T_dur && $abstime < 15n + Twrite_dur) ?
                    ((row15_value_left >> 9) & 1 ? v_high : v_low) : v_low, 0, trise);
	V(in2[9]) <+ transition(($abstime >= 15n + T_dur && $abstime < 15n + Twrite_dur) ?
                    ((row15_value_right >> 9) & 1 ? v_high : v_low) : v_low, 0, trise);
	V(in1[10]) <+ transition(($abstime >= 15n + T_dur && $abstime < 15n + Twrite_dur) ?
                    ((row15_value_left >> 10) & 1 ? v_high : v_low) : v_low, 0, trise);
	V(in2[10]) <+ transition(($abstime >= 15n + T_dur && $abstime < 15n + Twrite_dur) ?
                    ((row15_value_right >> 10) & 1 ? v_high : v_low) : v_low, 0, trise);
	V(in1[11]) <+ transition(($abstime >= 15n + T_dur && $abstime < 15n + Twrite_dur) ?
                    ((row15_value_left >> 11) & 1 ? v_high : v_low) : v_low, 0, trise);
	V(in2[11]) <+ transition(($abstime >= 15n + T_dur && $abstime < 15n + Twrite_dur) ?
                    ((row15_value_right >> 11) & 1 ? v_high : v_low) : v_low, 0, trise);
	V(in1[12]) <+ transition(($abstime >= 15n + T_dur && $abstime < 15n + Twrite_dur) ?
                    ((row15_value_left >> 12) & 1 ? v_high : v_low) : v_low, 0, trise);
	V(in2[12]) <+ transition(($abstime >= 15n + T_dur && $abstime < 15n + Twrite_dur) ?
                    ((row15_value_right >> 12) & 1 ? v_high : v_low) : v_low, 0, trise);
	V(in1[13]) <+ transition(($abstime >= 15n + T_dur && $abstime < 15n + Twrite_dur) ?
                    ((row15_value_left >> 13) & 1 ? v_high : v_low) : v_low, 0, trise);
	V(in2[13]) <+ transition(($abstime >= 15n + T_dur && $abstime < 15n + Twrite_dur) ?
                    ((row15_value_right >> 13) & 1 ? v_high : v_low) : v_low, 0, trise);
	V(in1[14]) <+ transition(($abstime >= 15n + T_dur && $abstime < 15n + Twrite_dur) ?
                    ((row15_value_left >> 14) & 1 ? v_high : v_low) : v_low, 0, trise);
	V(in2[14]) <+ transition(($abstime >= 15n + T_dur && $abstime < 15n + Twrite_dur) ?
                    ((row15_value_right >> 14) & 1 ? v_high : v_low) : v_low, 0, trise);
	V(in1[15]) <+ transition(($abstime >= 15n + T_dur && $abstime < 15n + Twrite_dur) ?
                    ((row15_value_left >> 15) & 1 ? v_high : v_low) : v_low, 0, trise);
	V(in2[15]) <+ transition(($abstime >= 15n + T_dur && $abstime < 15n + Twrite_dur) ?
                    ((row15_value_right >> 15) & 1 ? v_high : v_low) : v_low, 0, trise);
	V(in1[16]) <+ transition(($abstime >= 15n + T_dur && $abstime < 15n + Twrite_dur) ?
                    ((row15_value_left >> 16) & 1 ? v_high : v_low) : v_low, 0, trise);
	V(in2[16]) <+ transition(($abstime >= 15n + T_dur && $abstime < 15n + Twrite_dur) ?
                    ((row15_value_right >> 16) & 1 ? v_high : v_low) : v_low, 0, trise);
	V(in1[17]) <+ transition(($abstime >= 15n + T_dur && $abstime < 15n + Twrite_dur) ?
                    ((row15_value_left >> 17) & 1 ? v_high : v_low) : v_low, 0, trise);
	V(in2[17]) <+ transition(($abstime >= 15n + T_dur && $abstime < 15n + Twrite_dur) ?
                    ((row15_value_right >> 17) & 1 ? v_high : v_low) : v_low, 0, trise);
	V(in1[18]) <+ transition(($abstime >= 15n + T_dur && $abstime < 15n + Twrite_dur) ?
                    ((row15_value_left >> 18) & 1 ? v_high : v_low) : v_low, 0, trise);
	V(in2[18]) <+ transition(($abstime >= 15n + T_dur && $abstime < 15n + Twrite_dur) ?
                    ((row15_value_right >> 18) & 1 ? v_high : v_low) : v_low, 0, trise);
	V(in1[19]) <+ transition(($abstime >= 15n + T_dur && $abstime < 15n + Twrite_dur) ?
                    ((row15_value_left >> 19) & 1 ? v_high : v_low) : v_low, 0, trise);
	V(in2[19]) <+ transition(($abstime >= 15n + T_dur && $abstime < 15n + Twrite_dur) ?
                    ((row15_value_right >> 19) & 1 ? v_high : v_low) : v_low, 0, trise);
	V(in1[20]) <+ transition(($abstime >= 15n + T_dur && $abstime < 15n + Twrite_dur) ?
                    ((row15_value_left >> 20) & 1 ? v_high : v_low) : v_low, 0, trise);
	V(in2[20]) <+ transition(($abstime >= 15n + T_dur && $abstime < 15n + Twrite_dur) ?
                    ((row15_value_right >> 20) & 1 ? v_high : v_low) : v_low, 0, trise);
	V(in1[21]) <+ transition(($abstime >= 15n + T_dur && $abstime < 15n + Twrite_dur) ?
                    ((row15_value_left >> 21) & 1 ? v_high : v_low) : v_low, 0, trise);
	V(in2[21]) <+ transition(($abstime >= 15n + T_dur && $abstime < 15n + Twrite_dur) ?
                    ((row15_value_right >> 21) & 1 ? v_high : v_low) : v_low, 0, trise);
	V(in1[22]) <+ transition(($abstime >= 15n + T_dur && $abstime < 15n + Twrite_dur) ?
                    ((row15_value_left >> 22) & 1 ? v_high : v_low) : v_low, 0, trise);
	V(in2[22]) <+ transition(($abstime >= 15n + T_dur && $abstime < 15n + Twrite_dur) ?
                    ((row15_value_right >> 22) & 1 ? v_high : v_low) : v_low, 0, trise);
	V(in1[23]) <+ transition(($abstime >= 15n + T_dur && $abstime < 15n + Twrite_dur) ?
                    ((row15_value_left >> 23) & 1 ? v_high : v_low) : v_low, 0, trise);
	V(in2[23]) <+ transition(($abstime >= 15n + T_dur && $abstime < 15n + Twrite_dur) ?
                    ((row15_value_right >> 23) & 1 ? v_high : v_low) : v_low, 0, trise);
	V(in1[24]) <+ transition(($abstime >= 15n + T_dur && $abstime < 15n + Twrite_dur) ?
                    ((row15_value_left >> 24) & 1 ? v_high : v_low) : v_low, 0, trise);
	V(in2[24]) <+ transition(($abstime >= 15n + T_dur && $abstime < 15n + Twrite_dur) ?
                    ((row15_value_right >> 24) & 1 ? v_high : v_low) : v_low, 0, trise);
	V(in1[25]) <+ transition(($abstime >= 15n + T_dur && $abstime < 15n + Twrite_dur) ?
                    ((row15_value_left >> 25) & 1 ? v_high : v_low) : v_low, 0, trise);
	V(in2[25]) <+ transition(($abstime >= 15n + T_dur && $abstime < 15n + Twrite_dur) ?
                    ((row15_value_right >> 25) & 1 ? v_high : v_low) : v_low, 0, trise);
	V(in1[26]) <+ transition(($abstime >= 15n + T_dur && $abstime < 15n + Twrite_dur) ?
                    ((row15_value_left >> 26) & 1 ? v_high : v_low) : v_low, 0, trise);
	V(in2[26]) <+ transition(($abstime >= 15n + T_dur && $abstime < 15n + Twrite_dur) ?
                    ((row15_value_right >> 26) & 1 ? v_high : v_low) : v_low, 0, trise);
	V(in1[27]) <+ transition(($abstime >= 15n + T_dur && $abstime < 15n + Twrite_dur) ?
                    ((row15_value_left >> 27) & 1 ? v_high : v_low) : v_low, 0, trise);
	V(in2[27]) <+ transition(($abstime >= 15n + T_dur && $abstime < 15n + Twrite_dur) ?
                    ((row15_value_right >> 27) & 1 ? v_high : v_low) : v_low, 0, trise);
	V(in1[28]) <+ transition(($abstime >= 15n + T_dur && $abstime < 15n + Twrite_dur) ?
                    ((row15_value_left >> 28) & 1 ? v_high : v_low) : v_low, 0, trise);
	V(in2[28]) <+ transition(($abstime >= 15n + T_dur && $abstime < 15n + Twrite_dur) ?
                    ((row15_value_right >> 28) & 1 ? v_high : v_low) : v_low, 0, trise);
	V(in1[29]) <+ transition(($abstime >= 15n + T_dur && $abstime < 15n + Twrite_dur) ?
                    ((row15_value_left >> 29) & 1 ? v_high : v_low) : v_low, 0, trise);
	V(in2[29]) <+ transition(($abstime >= 15n + T_dur && $abstime < 15n + Twrite_dur) ?
                    ((row15_value_right >> 29) & 1 ? v_high : v_low) : v_low, 0, trise);
	V(in1[30]) <+ transition(($abstime >= 15n + T_dur && $abstime < 15n + Twrite_dur) ?
                    ((row15_value_left >> 30) & 1 ? v_high : v_low) : v_low, 0, trise);
	V(in2[30]) <+ transition(($abstime >= 15n + T_dur && $abstime < 15n + Twrite_dur) ?
                    ((row15_value_right >> 30) & 1 ? v_high : v_low) : v_low, 0, trise);
	V(in1[31]) <+ transition(($abstime >= 15n + T_dur && $abstime < 15n + Twrite_dur) ?
                    ((row15_value_left >> 31) & 1 ? v_high : v_low) : v_low, 0, trise);
	V(in2[31]) <+ transition(($abstime >= 15n + T_dur && $abstime < 15n + Twrite_dur) ?
                    ((row15_value_right >> 31) & 1 ? v_high : v_low) : v_low, 0, trise);

    V(write) <+ transition(($abstime >= 16n + T_dur && $abstime < 16n + Twrite_dur) ? v_high : v_low, 0, trise);
    V(WL[16]) <+ transition(($abstime >= 16n + T_dur && $abstime < 16n + TWL_dur) ? v_high : v_low, 0, trise);
	V(in1[0]) <+ transition(($abstime >= 16n + T_dur && $abstime < 16n + Twrite_dur) ?
                    ((row16_value_left >> 0) & 1 ? v_high : v_low) : v_low, 0, trise);
	V(in2[0]) <+ transition(($abstime >= 16n + T_dur && $abstime < 16n + Twrite_dur) ?
                    ((row16_value_right >> 0) & 1 ? v_high : v_low) : v_low, 0, trise);
	V(in1[1]) <+ transition(($abstime >= 16n + T_dur && $abstime < 16n + Twrite_dur) ?
                    ((row16_value_left >> 1) & 1 ? v_high : v_low) : v_low, 0, trise);
	V(in2[1]) <+ transition(($abstime >= 16n + T_dur && $abstime < 16n + Twrite_dur) ?
                    ((row16_value_right >> 1) & 1 ? v_high : v_low) : v_low, 0, trise);
	V(in1[2]) <+ transition(($abstime >= 16n + T_dur && $abstime < 16n + Twrite_dur) ?
                    ((row16_value_left >> 2) & 1 ? v_high : v_low) : v_low, 0, trise);
	V(in2[2]) <+ transition(($abstime >= 16n + T_dur && $abstime < 16n + Twrite_dur) ?
                    ((row16_value_right >> 2) & 1 ? v_high : v_low) : v_low, 0, trise);
	V(in1[3]) <+ transition(($abstime >= 16n + T_dur && $abstime < 16n + Twrite_dur) ?
                    ((row16_value_left >> 3) & 1 ? v_high : v_low) : v_low, 0, trise);
	V(in2[3]) <+ transition(($abstime >= 16n + T_dur && $abstime < 16n + Twrite_dur) ?
                    ((row16_value_right >> 3) & 1 ? v_high : v_low) : v_low, 0, trise);
	V(in1[4]) <+ transition(($abstime >= 16n + T_dur && $abstime < 16n + Twrite_dur) ?
                    ((row16_value_left >> 4) & 1 ? v_high : v_low) : v_low, 0, trise);
	V(in2[4]) <+ transition(($abstime >= 16n + T_dur && $abstime < 16n + Twrite_dur) ?
                    ((row16_value_right >> 4) & 1 ? v_high : v_low) : v_low, 0, trise);
	V(in1[5]) <+ transition(($abstime >= 16n + T_dur && $abstime < 16n + Twrite_dur) ?
                    ((row16_value_left >> 5) & 1 ? v_high : v_low) : v_low, 0, trise);
	V(in2[5]) <+ transition(($abstime >= 16n + T_dur && $abstime < 16n + Twrite_dur) ?
                    ((row16_value_right >> 5) & 1 ? v_high : v_low) : v_low, 0, trise);
	V(in1[6]) <+ transition(($abstime >= 16n + T_dur && $abstime < 16n + Twrite_dur) ?
                    ((row16_value_left >> 6) & 1 ? v_high : v_low) : v_low, 0, trise);
	V(in2[6]) <+ transition(($abstime >= 16n + T_dur && $abstime < 16n + Twrite_dur) ?
                    ((row16_value_right >> 6) & 1 ? v_high : v_low) : v_low, 0, trise);
	V(in1[7]) <+ transition(($abstime >= 16n + T_dur && $abstime < 16n + Twrite_dur) ?
                    ((row16_value_left >> 7) & 1 ? v_high : v_low) : v_low, 0, trise);
	V(in2[7]) <+ transition(($abstime >= 16n + T_dur && $abstime < 16n + Twrite_dur) ?
                    ((row16_value_right >> 7) & 1 ? v_high : v_low) : v_low, 0, trise);
	V(in1[8]) <+ transition(($abstime >= 16n + T_dur && $abstime < 16n + Twrite_dur) ?
                    ((row16_value_left >> 8) & 1 ? v_high : v_low) : v_low, 0, trise);
	V(in2[8]) <+ transition(($abstime >= 16n + T_dur && $abstime < 16n + Twrite_dur) ?
                    ((row16_value_right >> 8) & 1 ? v_high : v_low) : v_low, 0, trise);
	V(in1[9]) <+ transition(($abstime >= 16n + T_dur && $abstime < 16n + Twrite_dur) ?
                    ((row16_value_left >> 9) & 1 ? v_high : v_low) : v_low, 0, trise);
	V(in2[9]) <+ transition(($abstime >= 16n + T_dur && $abstime < 16n + Twrite_dur) ?
                    ((row16_value_right >> 9) & 1 ? v_high : v_low) : v_low, 0, trise);
	V(in1[10]) <+ transition(($abstime >= 16n + T_dur && $abstime < 16n + Twrite_dur) ?
                    ((row16_value_left >> 10) & 1 ? v_high : v_low) : v_low, 0, trise);
	V(in2[10]) <+ transition(($abstime >= 16n + T_dur && $abstime < 16n + Twrite_dur) ?
                    ((row16_value_right >> 10) & 1 ? v_high : v_low) : v_low, 0, trise);
	V(in1[11]) <+ transition(($abstime >= 16n + T_dur && $abstime < 16n + Twrite_dur) ?
                    ((row16_value_left >> 11) & 1 ? v_high : v_low) : v_low, 0, trise);
	V(in2[11]) <+ transition(($abstime >= 16n + T_dur && $abstime < 16n + Twrite_dur) ?
                    ((row16_value_right >> 11) & 1 ? v_high : v_low) : v_low, 0, trise);
	V(in1[12]) <+ transition(($abstime >= 16n + T_dur && $abstime < 16n + Twrite_dur) ?
                    ((row16_value_left >> 12) & 1 ? v_high : v_low) : v_low, 0, trise);
	V(in2[12]) <+ transition(($abstime >= 16n + T_dur && $abstime < 16n + Twrite_dur) ?
                    ((row16_value_right >> 12) & 1 ? v_high : v_low) : v_low, 0, trise);
	V(in1[13]) <+ transition(($abstime >= 16n + T_dur && $abstime < 16n + Twrite_dur) ?
                    ((row16_value_left >> 13) & 1 ? v_high : v_low) : v_low, 0, trise);
	V(in2[13]) <+ transition(($abstime >= 16n + T_dur && $abstime < 16n + Twrite_dur) ?
                    ((row16_value_right >> 13) & 1 ? v_high : v_low) : v_low, 0, trise);
	V(in1[14]) <+ transition(($abstime >= 16n + T_dur && $abstime < 16n + Twrite_dur) ?
                    ((row16_value_left >> 14) & 1 ? v_high : v_low) : v_low, 0, trise);
	V(in2[14]) <+ transition(($abstime >= 16n + T_dur && $abstime < 16n + Twrite_dur) ?
                    ((row16_value_right >> 14) & 1 ? v_high : v_low) : v_low, 0, trise);
	V(in1[15]) <+ transition(($abstime >= 16n + T_dur && $abstime < 16n + Twrite_dur) ?
                    ((row16_value_left >> 15) & 1 ? v_high : v_low) : v_low, 0, trise);
	V(in2[15]) <+ transition(($abstime >= 16n + T_dur && $abstime < 16n + Twrite_dur) ?
                    ((row16_value_right >> 15) & 1 ? v_high : v_low) : v_low, 0, trise);
	V(in1[16]) <+ transition(($abstime >= 16n + T_dur && $abstime < 16n + Twrite_dur) ?
                    ((row16_value_left >> 16) & 1 ? v_high : v_low) : v_low, 0, trise);
	V(in2[16]) <+ transition(($abstime >= 16n + T_dur && $abstime < 16n + Twrite_dur) ?
                    ((row16_value_right >> 16) & 1 ? v_high : v_low) : v_low, 0, trise);
	V(in1[17]) <+ transition(($abstime >= 16n + T_dur && $abstime < 16n + Twrite_dur) ?
                    ((row16_value_left >> 17) & 1 ? v_high : v_low) : v_low, 0, trise);
	V(in2[17]) <+ transition(($abstime >= 16n + T_dur && $abstime < 16n + Twrite_dur) ?
                    ((row16_value_right >> 17) & 1 ? v_high : v_low) : v_low, 0, trise);
	V(in1[18]) <+ transition(($abstime >= 16n + T_dur && $abstime < 16n + Twrite_dur) ?
                    ((row16_value_left >> 18) & 1 ? v_high : v_low) : v_low, 0, trise);
	V(in2[18]) <+ transition(($abstime >= 16n + T_dur && $abstime < 16n + Twrite_dur) ?
                    ((row16_value_right >> 18) & 1 ? v_high : v_low) : v_low, 0, trise);
	V(in1[19]) <+ transition(($abstime >= 16n + T_dur && $abstime < 16n + Twrite_dur) ?
                    ((row16_value_left >> 19) & 1 ? v_high : v_low) : v_low, 0, trise);
	V(in2[19]) <+ transition(($abstime >= 16n + T_dur && $abstime < 16n + Twrite_dur) ?
                    ((row16_value_right >> 19) & 1 ? v_high : v_low) : v_low, 0, trise);
	V(in1[20]) <+ transition(($abstime >= 16n + T_dur && $abstime < 16n + Twrite_dur) ?
                    ((row16_value_left >> 20) & 1 ? v_high : v_low) : v_low, 0, trise);
	V(in2[20]) <+ transition(($abstime >= 16n + T_dur && $abstime < 16n + Twrite_dur) ?
                    ((row16_value_right >> 20) & 1 ? v_high : v_low) : v_low, 0, trise);
	V(in1[21]) <+ transition(($abstime >= 16n + T_dur && $abstime < 16n + Twrite_dur) ?
                    ((row16_value_left >> 21) & 1 ? v_high : v_low) : v_low, 0, trise);
	V(in2[21]) <+ transition(($abstime >= 16n + T_dur && $abstime < 16n + Twrite_dur) ?
                    ((row16_value_right >> 21) & 1 ? v_high : v_low) : v_low, 0, trise);
	V(in1[22]) <+ transition(($abstime >= 16n + T_dur && $abstime < 16n + Twrite_dur) ?
                    ((row16_value_left >> 22) & 1 ? v_high : v_low) : v_low, 0, trise);
	V(in2[22]) <+ transition(($abstime >= 16n + T_dur && $abstime < 16n + Twrite_dur) ?
                    ((row16_value_right >> 22) & 1 ? v_high : v_low) : v_low, 0, trise);
	V(in1[23]) <+ transition(($abstime >= 16n + T_dur && $abstime < 16n + Twrite_dur) ?
                    ((row16_value_left >> 23) & 1 ? v_high : v_low) : v_low, 0, trise);
	V(in2[23]) <+ transition(($abstime >= 16n + T_dur && $abstime < 16n + Twrite_dur) ?
                    ((row16_value_right >> 23) & 1 ? v_high : v_low) : v_low, 0, trise);
	V(in1[24]) <+ transition(($abstime >= 16n + T_dur && $abstime < 16n + Twrite_dur) ?
                    ((row16_value_left >> 24) & 1 ? v_high : v_low) : v_low, 0, trise);
	V(in2[24]) <+ transition(($abstime >= 16n + T_dur && $abstime < 16n + Twrite_dur) ?
                    ((row16_value_right >> 24) & 1 ? v_high : v_low) : v_low, 0, trise);
	V(in1[25]) <+ transition(($abstime >= 16n + T_dur && $abstime < 16n + Twrite_dur) ?
                    ((row16_value_left >> 25) & 1 ? v_high : v_low) : v_low, 0, trise);
	V(in2[25]) <+ transition(($abstime >= 16n + T_dur && $abstime < 16n + Twrite_dur) ?
                    ((row16_value_right >> 25) & 1 ? v_high : v_low) : v_low, 0, trise);
	V(in1[26]) <+ transition(($abstime >= 16n + T_dur && $abstime < 16n + Twrite_dur) ?
                    ((row16_value_left >> 26) & 1 ? v_high : v_low) : v_low, 0, trise);
	V(in2[26]) <+ transition(($abstime >= 16n + T_dur && $abstime < 16n + Twrite_dur) ?
                    ((row16_value_right >> 26) & 1 ? v_high : v_low) : v_low, 0, trise);
	V(in1[27]) <+ transition(($abstime >= 16n + T_dur && $abstime < 16n + Twrite_dur) ?
                    ((row16_value_left >> 27) & 1 ? v_high : v_low) : v_low, 0, trise);
	V(in2[27]) <+ transition(($abstime >= 16n + T_dur && $abstime < 16n + Twrite_dur) ?
                    ((row16_value_right >> 27) & 1 ? v_high : v_low) : v_low, 0, trise);
	V(in1[28]) <+ transition(($abstime >= 16n + T_dur && $abstime < 16n + Twrite_dur) ?
                    ((row16_value_left >> 28) & 1 ? v_high : v_low) : v_low, 0, trise);
	V(in2[28]) <+ transition(($abstime >= 16n + T_dur && $abstime < 16n + Twrite_dur) ?
                    ((row16_value_right >> 28) & 1 ? v_high : v_low) : v_low, 0, trise);
	V(in1[29]) <+ transition(($abstime >= 16n + T_dur && $abstime < 16n + Twrite_dur) ?
                    ((row16_value_left >> 29) & 1 ? v_high : v_low) : v_low, 0, trise);
	V(in2[29]) <+ transition(($abstime >= 16n + T_dur && $abstime < 16n + Twrite_dur) ?
                    ((row16_value_right >> 29) & 1 ? v_high : v_low) : v_low, 0, trise);
	V(in1[30]) <+ transition(($abstime >= 16n + T_dur && $abstime < 16n + Twrite_dur) ?
                    ((row16_value_left >> 30) & 1 ? v_high : v_low) : v_low, 0, trise);
	V(in2[30]) <+ transition(($abstime >= 16n + T_dur && $abstime < 16n + Twrite_dur) ?
                    ((row16_value_right >> 30) & 1 ? v_high : v_low) : v_low, 0, trise);
	V(in1[31]) <+ transition(($abstime >= 16n + T_dur && $abstime < 16n + Twrite_dur) ?
                    ((row16_value_left >> 31) & 1 ? v_high : v_low) : v_low, 0, trise);
	V(in2[31]) <+ transition(($abstime >= 16n + T_dur && $abstime < 16n + Twrite_dur) ?
                    ((row16_value_right >> 31) & 1 ? v_high : v_low) : v_low, 0, trise);

    V(write) <+ transition(($abstime >= 17n + T_dur && $abstime < 17n + Twrite_dur) ? v_high : v_low, 0, trise);
    V(WL[17]) <+ transition(($abstime >= 17n + T_dur && $abstime < 17n + TWL_dur) ? v_high : v_low, 0, trise);
	V(in1[0]) <+ transition(($abstime >= 17n + T_dur && $abstime < 17n + Twrite_dur) ?
                    ((row17_value_left >> 0) & 1 ? v_high : v_low) : v_low, 0, trise);
	V(in2[0]) <+ transition(($abstime >= 17n + T_dur && $abstime < 17n + Twrite_dur) ?
                    ((row17_value_right >> 0) & 1 ? v_high : v_low) : v_low, 0, trise);
	V(in1[1]) <+ transition(($abstime >= 17n + T_dur && $abstime < 17n + Twrite_dur) ?
                    ((row17_value_left >> 1) & 1 ? v_high : v_low) : v_low, 0, trise);
	V(in2[1]) <+ transition(($abstime >= 17n + T_dur && $abstime < 17n + Twrite_dur) ?
                    ((row17_value_right >> 1) & 1 ? v_high : v_low) : v_low, 0, trise);
	V(in1[2]) <+ transition(($abstime >= 17n + T_dur && $abstime < 17n + Twrite_dur) ?
                    ((row17_value_left >> 2) & 1 ? v_high : v_low) : v_low, 0, trise);
	V(in2[2]) <+ transition(($abstime >= 17n + T_dur && $abstime < 17n + Twrite_dur) ?
                    ((row17_value_right >> 2) & 1 ? v_high : v_low) : v_low, 0, trise);
	V(in1[3]) <+ transition(($abstime >= 17n + T_dur && $abstime < 17n + Twrite_dur) ?
                    ((row17_value_left >> 3) & 1 ? v_high : v_low) : v_low, 0, trise);
	V(in2[3]) <+ transition(($abstime >= 17n + T_dur && $abstime < 17n + Twrite_dur) ?
                    ((row17_value_right >> 3) & 1 ? v_high : v_low) : v_low, 0, trise);
	V(in1[4]) <+ transition(($abstime >= 17n + T_dur && $abstime < 17n + Twrite_dur) ?
                    ((row17_value_left >> 4) & 1 ? v_high : v_low) : v_low, 0, trise);
	V(in2[4]) <+ transition(($abstime >= 17n + T_dur && $abstime < 17n + Twrite_dur) ?
                    ((row17_value_right >> 4) & 1 ? v_high : v_low) : v_low, 0, trise);
	V(in1[5]) <+ transition(($abstime >= 17n + T_dur && $abstime < 17n + Twrite_dur) ?
                    ((row17_value_left >> 5) & 1 ? v_high : v_low) : v_low, 0, trise);
	V(in2[5]) <+ transition(($abstime >= 17n + T_dur && $abstime < 17n + Twrite_dur) ?
                    ((row17_value_right >> 5) & 1 ? v_high : v_low) : v_low, 0, trise);
	V(in1[6]) <+ transition(($abstime >= 17n + T_dur && $abstime < 17n + Twrite_dur) ?
                    ((row17_value_left >> 6) & 1 ? v_high : v_low) : v_low, 0, trise);
	V(in2[6]) <+ transition(($abstime >= 17n + T_dur && $abstime < 17n + Twrite_dur) ?
                    ((row17_value_right >> 6) & 1 ? v_high : v_low) : v_low, 0, trise);
	V(in1[7]) <+ transition(($abstime >= 17n + T_dur && $abstime < 17n + Twrite_dur) ?
                    ((row17_value_left >> 7) & 1 ? v_high : v_low) : v_low, 0, trise);
	V(in2[7]) <+ transition(($abstime >= 17n + T_dur && $abstime < 17n + Twrite_dur) ?
                    ((row17_value_right >> 7) & 1 ? v_high : v_low) : v_low, 0, trise);
	V(in1[8]) <+ transition(($abstime >= 17n + T_dur && $abstime < 17n + Twrite_dur) ?
                    ((row17_value_left >> 8) & 1 ? v_high : v_low) : v_low, 0, trise);
	V(in2[8]) <+ transition(($abstime >= 17n + T_dur && $abstime < 17n + Twrite_dur) ?
                    ((row17_value_right >> 8) & 1 ? v_high : v_low) : v_low, 0, trise);
	V(in1[9]) <+ transition(($abstime >= 17n + T_dur && $abstime < 17n + Twrite_dur) ?
                    ((row17_value_left >> 9) & 1 ? v_high : v_low) : v_low, 0, trise);
	V(in2[9]) <+ transition(($abstime >= 17n + T_dur && $abstime < 17n + Twrite_dur) ?
                    ((row17_value_right >> 9) & 1 ? v_high : v_low) : v_low, 0, trise);
	V(in1[10]) <+ transition(($abstime >= 17n + T_dur && $abstime < 17n + Twrite_dur) ?
                    ((row17_value_left >> 10) & 1 ? v_high : v_low) : v_low, 0, trise);
	V(in2[10]) <+ transition(($abstime >= 17n + T_dur && $abstime < 17n + Twrite_dur) ?
                    ((row17_value_right >> 10) & 1 ? v_high : v_low) : v_low, 0, trise);
	V(in1[11]) <+ transition(($abstime >= 17n + T_dur && $abstime < 17n + Twrite_dur) ?
                    ((row17_value_left >> 11) & 1 ? v_high : v_low) : v_low, 0, trise);
	V(in2[11]) <+ transition(($abstime >= 17n + T_dur && $abstime < 17n + Twrite_dur) ?
                    ((row17_value_right >> 11) & 1 ? v_high : v_low) : v_low, 0, trise);
	V(in1[12]) <+ transition(($abstime >= 17n + T_dur && $abstime < 17n + Twrite_dur) ?
                    ((row17_value_left >> 12) & 1 ? v_high : v_low) : v_low, 0, trise);
	V(in2[12]) <+ transition(($abstime >= 17n + T_dur && $abstime < 17n + Twrite_dur) ?
                    ((row17_value_right >> 12) & 1 ? v_high : v_low) : v_low, 0, trise);
	V(in1[13]) <+ transition(($abstime >= 17n + T_dur && $abstime < 17n + Twrite_dur) ?
                    ((row17_value_left >> 13) & 1 ? v_high : v_low) : v_low, 0, trise);
	V(in2[13]) <+ transition(($abstime >= 17n + T_dur && $abstime < 17n + Twrite_dur) ?
                    ((row17_value_right >> 13) & 1 ? v_high : v_low) : v_low, 0, trise);
	V(in1[14]) <+ transition(($abstime >= 17n + T_dur && $abstime < 17n + Twrite_dur) ?
                    ((row17_value_left >> 14) & 1 ? v_high : v_low) : v_low, 0, trise);
	V(in2[14]) <+ transition(($abstime >= 17n + T_dur && $abstime < 17n + Twrite_dur) ?
                    ((row17_value_right >> 14) & 1 ? v_high : v_low) : v_low, 0, trise);
	V(in1[15]) <+ transition(($abstime >= 17n + T_dur && $abstime < 17n + Twrite_dur) ?
                    ((row17_value_left >> 15) & 1 ? v_high : v_low) : v_low, 0, trise);
	V(in2[15]) <+ transition(($abstime >= 17n + T_dur && $abstime < 17n + Twrite_dur) ?
                    ((row17_value_right >> 15) & 1 ? v_high : v_low) : v_low, 0, trise);
	V(in1[16]) <+ transition(($abstime >= 17n + T_dur && $abstime < 17n + Twrite_dur) ?
                    ((row17_value_left >> 16) & 1 ? v_high : v_low) : v_low, 0, trise);
	V(in2[16]) <+ transition(($abstime >= 17n + T_dur && $abstime < 17n + Twrite_dur) ?
                    ((row17_value_right >> 16) & 1 ? v_high : v_low) : v_low, 0, trise);
	V(in1[17]) <+ transition(($abstime >= 17n + T_dur && $abstime < 17n + Twrite_dur) ?
                    ((row17_value_left >> 17) & 1 ? v_high : v_low) : v_low, 0, trise);
	V(in2[17]) <+ transition(($abstime >= 17n + T_dur && $abstime < 17n + Twrite_dur) ?
                    ((row17_value_right >> 17) & 1 ? v_high : v_low) : v_low, 0, trise);
	V(in1[18]) <+ transition(($abstime >= 17n + T_dur && $abstime < 17n + Twrite_dur) ?
                    ((row17_value_left >> 18) & 1 ? v_high : v_low) : v_low, 0, trise);
	V(in2[18]) <+ transition(($abstime >= 17n + T_dur && $abstime < 17n + Twrite_dur) ?
                    ((row17_value_right >> 18) & 1 ? v_high : v_low) : v_low, 0, trise);
	V(in1[19]) <+ transition(($abstime >= 17n + T_dur && $abstime < 17n + Twrite_dur) ?
                    ((row17_value_left >> 19) & 1 ? v_high : v_low) : v_low, 0, trise);
	V(in2[19]) <+ transition(($abstime >= 17n + T_dur && $abstime < 17n + Twrite_dur) ?
                    ((row17_value_right >> 19) & 1 ? v_high : v_low) : v_low, 0, trise);
	V(in1[20]) <+ transition(($abstime >= 17n + T_dur && $abstime < 17n + Twrite_dur) ?
                    ((row17_value_left >> 20) & 1 ? v_high : v_low) : v_low, 0, trise);
	V(in2[20]) <+ transition(($abstime >= 17n + T_dur && $abstime < 17n + Twrite_dur) ?
                    ((row17_value_right >> 20) & 1 ? v_high : v_low) : v_low, 0, trise);
	V(in1[21]) <+ transition(($abstime >= 17n + T_dur && $abstime < 17n + Twrite_dur) ?
                    ((row17_value_left >> 21) & 1 ? v_high : v_low) : v_low, 0, trise);
	V(in2[21]) <+ transition(($abstime >= 17n + T_dur && $abstime < 17n + Twrite_dur) ?
                    ((row17_value_right >> 21) & 1 ? v_high : v_low) : v_low, 0, trise);
	V(in1[22]) <+ transition(($abstime >= 17n + T_dur && $abstime < 17n + Twrite_dur) ?
                    ((row17_value_left >> 22) & 1 ? v_high : v_low) : v_low, 0, trise);
	V(in2[22]) <+ transition(($abstime >= 17n + T_dur && $abstime < 17n + Twrite_dur) ?
                    ((row17_value_right >> 22) & 1 ? v_high : v_low) : v_low, 0, trise);
	V(in1[23]) <+ transition(($abstime >= 17n + T_dur && $abstime < 17n + Twrite_dur) ?
                    ((row17_value_left >> 23) & 1 ? v_high : v_low) : v_low, 0, trise);
	V(in2[23]) <+ transition(($abstime >= 17n + T_dur && $abstime < 17n + Twrite_dur) ?
                    ((row17_value_right >> 23) & 1 ? v_high : v_low) : v_low, 0, trise);
	V(in1[24]) <+ transition(($abstime >= 17n + T_dur && $abstime < 17n + Twrite_dur) ?
                    ((row17_value_left >> 24) & 1 ? v_high : v_low) : v_low, 0, trise);
	V(in2[24]) <+ transition(($abstime >= 17n + T_dur && $abstime < 17n + Twrite_dur) ?
                    ((row17_value_right >> 24) & 1 ? v_high : v_low) : v_low, 0, trise);
	V(in1[25]) <+ transition(($abstime >= 17n + T_dur && $abstime < 17n + Twrite_dur) ?
                    ((row17_value_left >> 25) & 1 ? v_high : v_low) : v_low, 0, trise);
	V(in2[25]) <+ transition(($abstime >= 17n + T_dur && $abstime < 17n + Twrite_dur) ?
                    ((row17_value_right >> 25) & 1 ? v_high : v_low) : v_low, 0, trise);
	V(in1[26]) <+ transition(($abstime >= 17n + T_dur && $abstime < 17n + Twrite_dur) ?
                    ((row17_value_left >> 26) & 1 ? v_high : v_low) : v_low, 0, trise);
	V(in2[26]) <+ transition(($abstime >= 17n + T_dur && $abstime < 17n + Twrite_dur) ?
                    ((row17_value_right >> 26) & 1 ? v_high : v_low) : v_low, 0, trise);
	V(in1[27]) <+ transition(($abstime >= 17n + T_dur && $abstime < 17n + Twrite_dur) ?
                    ((row17_value_left >> 27) & 1 ? v_high : v_low) : v_low, 0, trise);
	V(in2[27]) <+ transition(($abstime >= 17n + T_dur && $abstime < 17n + Twrite_dur) ?
                    ((row17_value_right >> 27) & 1 ? v_high : v_low) : v_low, 0, trise);
	V(in1[28]) <+ transition(($abstime >= 17n + T_dur && $abstime < 17n + Twrite_dur) ?
                    ((row17_value_left >> 28) & 1 ? v_high : v_low) : v_low, 0, trise);
	V(in2[28]) <+ transition(($abstime >= 17n + T_dur && $abstime < 17n + Twrite_dur) ?
                    ((row17_value_right >> 28) & 1 ? v_high : v_low) : v_low, 0, trise);
	V(in1[29]) <+ transition(($abstime >= 17n + T_dur && $abstime < 17n + Twrite_dur) ?
                    ((row17_value_left >> 29) & 1 ? v_high : v_low) : v_low, 0, trise);
	V(in2[29]) <+ transition(($abstime >= 17n + T_dur && $abstime < 17n + Twrite_dur) ?
                    ((row17_value_right >> 29) & 1 ? v_high : v_low) : v_low, 0, trise);
	V(in1[30]) <+ transition(($abstime >= 17n + T_dur && $abstime < 17n + Twrite_dur) ?
                    ((row17_value_left >> 30) & 1 ? v_high : v_low) : v_low, 0, trise);
	V(in2[30]) <+ transition(($abstime >= 17n + T_dur && $abstime < 17n + Twrite_dur) ?
                    ((row17_value_right >> 30) & 1 ? v_high : v_low) : v_low, 0, trise);
	V(in1[31]) <+ transition(($abstime >= 17n + T_dur && $abstime < 17n + Twrite_dur) ?
                    ((row17_value_left >> 31) & 1 ? v_high : v_low) : v_low, 0, trise);
	V(in2[31]) <+ transition(($abstime >= 17n + T_dur && $abstime < 17n + Twrite_dur) ?
                    ((row17_value_right >> 31) & 1 ? v_high : v_low) : v_low, 0, trise);

    V(write) <+ transition(($abstime >= 18n + T_dur && $abstime < 18n + Twrite_dur) ? v_high : v_low, 0, trise);
    V(WL[18]) <+ transition(($abstime >= 18n + T_dur && $abstime < 18n + TWL_dur) ? v_high : v_low, 0, trise);
	V(in1[0]) <+ transition(($abstime >= 18n + T_dur && $abstime < 18n + Twrite_dur) ?
                    ((row18_value_left >> 0) & 1 ? v_high : v_low) : v_low, 0, trise);
	V(in2[0]) <+ transition(($abstime >= 18n + T_dur && $abstime < 18n + Twrite_dur) ?
                    ((row18_value_right >> 0) & 1 ? v_high : v_low) : v_low, 0, trise);
	V(in1[1]) <+ transition(($abstime >= 18n + T_dur && $abstime < 18n + Twrite_dur) ?
                    ((row18_value_left >> 1) & 1 ? v_high : v_low) : v_low, 0, trise);
	V(in2[1]) <+ transition(($abstime >= 18n + T_dur && $abstime < 18n + Twrite_dur) ?
                    ((row18_value_right >> 1) & 1 ? v_high : v_low) : v_low, 0, trise);
	V(in1[2]) <+ transition(($abstime >= 18n + T_dur && $abstime < 18n + Twrite_dur) ?
                    ((row18_value_left >> 2) & 1 ? v_high : v_low) : v_low, 0, trise);
	V(in2[2]) <+ transition(($abstime >= 18n + T_dur && $abstime < 18n + Twrite_dur) ?
                    ((row18_value_right >> 2) & 1 ? v_high : v_low) : v_low, 0, trise);
	V(in1[3]) <+ transition(($abstime >= 18n + T_dur && $abstime < 18n + Twrite_dur) ?
                    ((row18_value_left >> 3) & 1 ? v_high : v_low) : v_low, 0, trise);
	V(in2[3]) <+ transition(($abstime >= 18n + T_dur && $abstime < 18n + Twrite_dur) ?
                    ((row18_value_right >> 3) & 1 ? v_high : v_low) : v_low, 0, trise);
	V(in1[4]) <+ transition(($abstime >= 18n + T_dur && $abstime < 18n + Twrite_dur) ?
                    ((row18_value_left >> 4) & 1 ? v_high : v_low) : v_low, 0, trise);
	V(in2[4]) <+ transition(($abstime >= 18n + T_dur && $abstime < 18n + Twrite_dur) ?
                    ((row18_value_right >> 4) & 1 ? v_high : v_low) : v_low, 0, trise);
	V(in1[5]) <+ transition(($abstime >= 18n + T_dur && $abstime < 18n + Twrite_dur) ?
                    ((row18_value_left >> 5) & 1 ? v_high : v_low) : v_low, 0, trise);
	V(in2[5]) <+ transition(($abstime >= 18n + T_dur && $abstime < 18n + Twrite_dur) ?
                    ((row18_value_right >> 5) & 1 ? v_high : v_low) : v_low, 0, trise);
	V(in1[6]) <+ transition(($abstime >= 18n + T_dur && $abstime < 18n + Twrite_dur) ?
                    ((row18_value_left >> 6) & 1 ? v_high : v_low) : v_low, 0, trise);
	V(in2[6]) <+ transition(($abstime >= 18n + T_dur && $abstime < 18n + Twrite_dur) ?
                    ((row18_value_right >> 6) & 1 ? v_high : v_low) : v_low, 0, trise);
	V(in1[7]) <+ transition(($abstime >= 18n + T_dur && $abstime < 18n + Twrite_dur) ?
                    ((row18_value_left >> 7) & 1 ? v_high : v_low) : v_low, 0, trise);
	V(in2[7]) <+ transition(($abstime >= 18n + T_dur && $abstime < 18n + Twrite_dur) ?
                    ((row18_value_right >> 7) & 1 ? v_high : v_low) : v_low, 0, trise);
	V(in1[8]) <+ transition(($abstime >= 18n + T_dur && $abstime < 18n + Twrite_dur) ?
                    ((row18_value_left >> 8) & 1 ? v_high : v_low) : v_low, 0, trise);
	V(in2[8]) <+ transition(($abstime >= 18n + T_dur && $abstime < 18n + Twrite_dur) ?
                    ((row18_value_right >> 8) & 1 ? v_high : v_low) : v_low, 0, trise);
	V(in1[9]) <+ transition(($abstime >= 18n + T_dur && $abstime < 18n + Twrite_dur) ?
                    ((row18_value_left >> 9) & 1 ? v_high : v_low) : v_low, 0, trise);
	V(in2[9]) <+ transition(($abstime >= 18n + T_dur && $abstime < 18n + Twrite_dur) ?
                    ((row18_value_right >> 9) & 1 ? v_high : v_low) : v_low, 0, trise);
	V(in1[10]) <+ transition(($abstime >= 18n + T_dur && $abstime < 18n + Twrite_dur) ?
                    ((row18_value_left >> 10) & 1 ? v_high : v_low) : v_low, 0, trise);
	V(in2[10]) <+ transition(($abstime >= 18n + T_dur && $abstime < 18n + Twrite_dur) ?
                    ((row18_value_right >> 10) & 1 ? v_high : v_low) : v_low, 0, trise);
	V(in1[11]) <+ transition(($abstime >= 18n + T_dur && $abstime < 18n + Twrite_dur) ?
                    ((row18_value_left >> 11) & 1 ? v_high : v_low) : v_low, 0, trise);
	V(in2[11]) <+ transition(($abstime >= 18n + T_dur && $abstime < 18n + Twrite_dur) ?
                    ((row18_value_right >> 11) & 1 ? v_high : v_low) : v_low, 0, trise);
	V(in1[12]) <+ transition(($abstime >= 18n + T_dur && $abstime < 18n + Twrite_dur) ?
                    ((row18_value_left >> 12) & 1 ? v_high : v_low) : v_low, 0, trise);
	V(in2[12]) <+ transition(($abstime >= 18n + T_dur && $abstime < 18n + Twrite_dur) ?
                    ((row18_value_right >> 12) & 1 ? v_high : v_low) : v_low, 0, trise);
	V(in1[13]) <+ transition(($abstime >= 18n + T_dur && $abstime < 18n + Twrite_dur) ?
                    ((row18_value_left >> 13) & 1 ? v_high : v_low) : v_low, 0, trise);
	V(in2[13]) <+ transition(($abstime >= 18n + T_dur && $abstime < 18n + Twrite_dur) ?
                    ((row18_value_right >> 13) & 1 ? v_high : v_low) : v_low, 0, trise);
	V(in1[14]) <+ transition(($abstime >= 18n + T_dur && $abstime < 18n + Twrite_dur) ?
                    ((row18_value_left >> 14) & 1 ? v_high : v_low) : v_low, 0, trise);
	V(in2[14]) <+ transition(($abstime >= 18n + T_dur && $abstime < 18n + Twrite_dur) ?
                    ((row18_value_right >> 14) & 1 ? v_high : v_low) : v_low, 0, trise);
	V(in1[15]) <+ transition(($abstime >= 18n + T_dur && $abstime < 18n + Twrite_dur) ?
                    ((row18_value_left >> 15) & 1 ? v_high : v_low) : v_low, 0, trise);
	V(in2[15]) <+ transition(($abstime >= 18n + T_dur && $abstime < 18n + Twrite_dur) ?
                    ((row18_value_right >> 15) & 1 ? v_high : v_low) : v_low, 0, trise);
	V(in1[16]) <+ transition(($abstime >= 18n + T_dur && $abstime < 18n + Twrite_dur) ?
                    ((row18_value_left >> 16) & 1 ? v_high : v_low) : v_low, 0, trise);
	V(in2[16]) <+ transition(($abstime >= 18n + T_dur && $abstime < 18n + Twrite_dur) ?
                    ((row18_value_right >> 16) & 1 ? v_high : v_low) : v_low, 0, trise);
	V(in1[17]) <+ transition(($abstime >= 18n + T_dur && $abstime < 18n + Twrite_dur) ?
                    ((row18_value_left >> 17) & 1 ? v_high : v_low) : v_low, 0, trise);
	V(in2[17]) <+ transition(($abstime >= 18n + T_dur && $abstime < 18n + Twrite_dur) ?
                    ((row18_value_right >> 17) & 1 ? v_high : v_low) : v_low, 0, trise);
	V(in1[18]) <+ transition(($abstime >= 18n + T_dur && $abstime < 18n + Twrite_dur) ?
                    ((row18_value_left >> 18) & 1 ? v_high : v_low) : v_low, 0, trise);
	V(in2[18]) <+ transition(($abstime >= 18n + T_dur && $abstime < 18n + Twrite_dur) ?
                    ((row18_value_right >> 18) & 1 ? v_high : v_low) : v_low, 0, trise);
	V(in1[19]) <+ transition(($abstime >= 18n + T_dur && $abstime < 18n + Twrite_dur) ?
                    ((row18_value_left >> 19) & 1 ? v_high : v_low) : v_low, 0, trise);
	V(in2[19]) <+ transition(($abstime >= 18n + T_dur && $abstime < 18n + Twrite_dur) ?
                    ((row18_value_right >> 19) & 1 ? v_high : v_low) : v_low, 0, trise);
	V(in1[20]) <+ transition(($abstime >= 18n + T_dur && $abstime < 18n + Twrite_dur) ?
                    ((row18_value_left >> 20) & 1 ? v_high : v_low) : v_low, 0, trise);
	V(in2[20]) <+ transition(($abstime >= 18n + T_dur && $abstime < 18n + Twrite_dur) ?
                    ((row18_value_right >> 20) & 1 ? v_high : v_low) : v_low, 0, trise);
	V(in1[21]) <+ transition(($abstime >= 18n + T_dur && $abstime < 18n + Twrite_dur) ?
                    ((row18_value_left >> 21) & 1 ? v_high : v_low) : v_low, 0, trise);
	V(in2[21]) <+ transition(($abstime >= 18n + T_dur && $abstime < 18n + Twrite_dur) ?
                    ((row18_value_right >> 21) & 1 ? v_high : v_low) : v_low, 0, trise);
	V(in1[22]) <+ transition(($abstime >= 18n + T_dur && $abstime < 18n + Twrite_dur) ?
                    ((row18_value_left >> 22) & 1 ? v_high : v_low) : v_low, 0, trise);
	V(in2[22]) <+ transition(($abstime >= 18n + T_dur && $abstime < 18n + Twrite_dur) ?
                    ((row18_value_right >> 22) & 1 ? v_high : v_low) : v_low, 0, trise);
	V(in1[23]) <+ transition(($abstime >= 18n + T_dur && $abstime < 18n + Twrite_dur) ?
                    ((row18_value_left >> 23) & 1 ? v_high : v_low) : v_low, 0, trise);
	V(in2[23]) <+ transition(($abstime >= 18n + T_dur && $abstime < 18n + Twrite_dur) ?
                    ((row18_value_right >> 23) & 1 ? v_high : v_low) : v_low, 0, trise);
	V(in1[24]) <+ transition(($abstime >= 18n + T_dur && $abstime < 18n + Twrite_dur) ?
                    ((row18_value_left >> 24) & 1 ? v_high : v_low) : v_low, 0, trise);
	V(in2[24]) <+ transition(($abstime >= 18n + T_dur && $abstime < 18n + Twrite_dur) ?
                    ((row18_value_right >> 24) & 1 ? v_high : v_low) : v_low, 0, trise);
	V(in1[25]) <+ transition(($abstime >= 18n + T_dur && $abstime < 18n + Twrite_dur) ?
                    ((row18_value_left >> 25) & 1 ? v_high : v_low) : v_low, 0, trise);
	V(in2[25]) <+ transition(($abstime >= 18n + T_dur && $abstime < 18n + Twrite_dur) ?
                    ((row18_value_right >> 25) & 1 ? v_high : v_low) : v_low, 0, trise);
	V(in1[26]) <+ transition(($abstime >= 18n + T_dur && $abstime < 18n + Twrite_dur) ?
                    ((row18_value_left >> 26) & 1 ? v_high : v_low) : v_low, 0, trise);
	V(in2[26]) <+ transition(($abstime >= 18n + T_dur && $abstime < 18n + Twrite_dur) ?
                    ((row18_value_right >> 26) & 1 ? v_high : v_low) : v_low, 0, trise);
	V(in1[27]) <+ transition(($abstime >= 18n + T_dur && $abstime < 18n + Twrite_dur) ?
                    ((row18_value_left >> 27) & 1 ? v_high : v_low) : v_low, 0, trise);
	V(in2[27]) <+ transition(($abstime >= 18n + T_dur && $abstime < 18n + Twrite_dur) ?
                    ((row18_value_right >> 27) & 1 ? v_high : v_low) : v_low, 0, trise);
	V(in1[28]) <+ transition(($abstime >= 18n + T_dur && $abstime < 18n + Twrite_dur) ?
                    ((row18_value_left >> 28) & 1 ? v_high : v_low) : v_low, 0, trise);
	V(in2[28]) <+ transition(($abstime >= 18n + T_dur && $abstime < 18n + Twrite_dur) ?
                    ((row18_value_right >> 28) & 1 ? v_high : v_low) : v_low, 0, trise);
	V(in1[29]) <+ transition(($abstime >= 18n + T_dur && $abstime < 18n + Twrite_dur) ?
                    ((row18_value_left >> 29) & 1 ? v_high : v_low) : v_low, 0, trise);
	V(in2[29]) <+ transition(($abstime >= 18n + T_dur && $abstime < 18n + Twrite_dur) ?
                    ((row18_value_right >> 29) & 1 ? v_high : v_low) : v_low, 0, trise);
	V(in1[30]) <+ transition(($abstime >= 18n + T_dur && $abstime < 18n + Twrite_dur) ?
                    ((row18_value_left >> 30) & 1 ? v_high : v_low) : v_low, 0, trise);
	V(in2[30]) <+ transition(($abstime >= 18n + T_dur && $abstime < 18n + Twrite_dur) ?
                    ((row18_value_right >> 30) & 1 ? v_high : v_low) : v_low, 0, trise);
	V(in1[31]) <+ transition(($abstime >= 18n + T_dur && $abstime < 18n + Twrite_dur) ?
                    ((row18_value_left >> 31) & 1 ? v_high : v_low) : v_low, 0, trise);
	V(in2[31]) <+ transition(($abstime >= 18n + T_dur && $abstime < 18n + Twrite_dur) ?
                    ((row18_value_right >> 31) & 1 ? v_high : v_low) : v_low, 0, trise);

    V(write) <+ transition(($abstime >= 19n + T_dur && $abstime < 19n + Twrite_dur) ? v_high : v_low, 0, trise);
    V(WL[19]) <+ transition(($abstime >= 19n + T_dur && $abstime < 19n + TWL_dur) ? v_high : v_low, 0, trise);
	V(in1[0]) <+ transition(($abstime >= 19n + T_dur && $abstime < 19n + Twrite_dur) ?
                    ((row19_value_left >> 0) & 1 ? v_high : v_low) : v_low, 0, trise);
	V(in2[0]) <+ transition(($abstime >= 19n + T_dur && $abstime < 19n + Twrite_dur) ?
                    ((row19_value_right >> 0) & 1 ? v_high : v_low) : v_low, 0, trise);
	V(in1[1]) <+ transition(($abstime >= 19n + T_dur && $abstime < 19n + Twrite_dur) ?
                    ((row19_value_left >> 1) & 1 ? v_high : v_low) : v_low, 0, trise);
	V(in2[1]) <+ transition(($abstime >= 19n + T_dur && $abstime < 19n + Twrite_dur) ?
                    ((row19_value_right >> 1) & 1 ? v_high : v_low) : v_low, 0, trise);
	V(in1[2]) <+ transition(($abstime >= 19n + T_dur && $abstime < 19n + Twrite_dur) ?
                    ((row19_value_left >> 2) & 1 ? v_high : v_low) : v_low, 0, trise);
	V(in2[2]) <+ transition(($abstime >= 19n + T_dur && $abstime < 19n + Twrite_dur) ?
                    ((row19_value_right >> 2) & 1 ? v_high : v_low) : v_low, 0, trise);
	V(in1[3]) <+ transition(($abstime >= 19n + T_dur && $abstime < 19n + Twrite_dur) ?
                    ((row19_value_left >> 3) & 1 ? v_high : v_low) : v_low, 0, trise);
	V(in2[3]) <+ transition(($abstime >= 19n + T_dur && $abstime < 19n + Twrite_dur) ?
                    ((row19_value_right >> 3) & 1 ? v_high : v_low) : v_low, 0, trise);
	V(in1[4]) <+ transition(($abstime >= 19n + T_dur && $abstime < 19n + Twrite_dur) ?
                    ((row19_value_left >> 4) & 1 ? v_high : v_low) : v_low, 0, trise);
	V(in2[4]) <+ transition(($abstime >= 19n + T_dur && $abstime < 19n + Twrite_dur) ?
                    ((row19_value_right >> 4) & 1 ? v_high : v_low) : v_low, 0, trise);
	V(in1[5]) <+ transition(($abstime >= 19n + T_dur && $abstime < 19n + Twrite_dur) ?
                    ((row19_value_left >> 5) & 1 ? v_high : v_low) : v_low, 0, trise);
	V(in2[5]) <+ transition(($abstime >= 19n + T_dur && $abstime < 19n + Twrite_dur) ?
                    ((row19_value_right >> 5) & 1 ? v_high : v_low) : v_low, 0, trise);
	V(in1[6]) <+ transition(($abstime >= 19n + T_dur && $abstime < 19n + Twrite_dur) ?
                    ((row19_value_left >> 6) & 1 ? v_high : v_low) : v_low, 0, trise);
	V(in2[6]) <+ transition(($abstime >= 19n + T_dur && $abstime < 19n + Twrite_dur) ?
                    ((row19_value_right >> 6) & 1 ? v_high : v_low) : v_low, 0, trise);
	V(in1[7]) <+ transition(($abstime >= 19n + T_dur && $abstime < 19n + Twrite_dur) ?
                    ((row19_value_left >> 7) & 1 ? v_high : v_low) : v_low, 0, trise);
	V(in2[7]) <+ transition(($abstime >= 19n + T_dur && $abstime < 19n + Twrite_dur) ?
                    ((row19_value_right >> 7) & 1 ? v_high : v_low) : v_low, 0, trise);
	V(in1[8]) <+ transition(($abstime >= 19n + T_dur && $abstime < 19n + Twrite_dur) ?
                    ((row19_value_left >> 8) & 1 ? v_high : v_low) : v_low, 0, trise);
	V(in2[8]) <+ transition(($abstime >= 19n + T_dur && $abstime < 19n + Twrite_dur) ?
                    ((row19_value_right >> 8) & 1 ? v_high : v_low) : v_low, 0, trise);
	V(in1[9]) <+ transition(($abstime >= 19n + T_dur && $abstime < 19n + Twrite_dur) ?
                    ((row19_value_left >> 9) & 1 ? v_high : v_low) : v_low, 0, trise);
	V(in2[9]) <+ transition(($abstime >= 19n + T_dur && $abstime < 19n + Twrite_dur) ?
                    ((row19_value_right >> 9) & 1 ? v_high : v_low) : v_low, 0, trise);
	V(in1[10]) <+ transition(($abstime >= 19n + T_dur && $abstime < 19n + Twrite_dur) ?
                    ((row19_value_left >> 10) & 1 ? v_high : v_low) : v_low, 0, trise);
	V(in2[10]) <+ transition(($abstime >= 19n + T_dur && $abstime < 19n + Twrite_dur) ?
                    ((row19_value_right >> 10) & 1 ? v_high : v_low) : v_low, 0, trise);
	V(in1[11]) <+ transition(($abstime >= 19n + T_dur && $abstime < 19n + Twrite_dur) ?
                    ((row19_value_left >> 11) & 1 ? v_high : v_low) : v_low, 0, trise);
	V(in2[11]) <+ transition(($abstime >= 19n + T_dur && $abstime < 19n + Twrite_dur) ?
                    ((row19_value_right >> 11) & 1 ? v_high : v_low) : v_low, 0, trise);
	V(in1[12]) <+ transition(($abstime >= 19n + T_dur && $abstime < 19n + Twrite_dur) ?
                    ((row19_value_left >> 12) & 1 ? v_high : v_low) : v_low, 0, trise);
	V(in2[12]) <+ transition(($abstime >= 19n + T_dur && $abstime < 19n + Twrite_dur) ?
                    ((row19_value_right >> 12) & 1 ? v_high : v_low) : v_low, 0, trise);
	V(in1[13]) <+ transition(($abstime >= 19n + T_dur && $abstime < 19n + Twrite_dur) ?
                    ((row19_value_left >> 13) & 1 ? v_high : v_low) : v_low, 0, trise);
	V(in2[13]) <+ transition(($abstime >= 19n + T_dur && $abstime < 19n + Twrite_dur) ?
                    ((row19_value_right >> 13) & 1 ? v_high : v_low) : v_low, 0, trise);
	V(in1[14]) <+ transition(($abstime >= 19n + T_dur && $abstime < 19n + Twrite_dur) ?
                    ((row19_value_left >> 14) & 1 ? v_high : v_low) : v_low, 0, trise);
	V(in2[14]) <+ transition(($abstime >= 19n + T_dur && $abstime < 19n + Twrite_dur) ?
                    ((row19_value_right >> 14) & 1 ? v_high : v_low) : v_low, 0, trise);
	V(in1[15]) <+ transition(($abstime >= 19n + T_dur && $abstime < 19n + Twrite_dur) ?
                    ((row19_value_left >> 15) & 1 ? v_high : v_low) : v_low, 0, trise);
	V(in2[15]) <+ transition(($abstime >= 19n + T_dur && $abstime < 19n + Twrite_dur) ?
                    ((row19_value_right >> 15) & 1 ? v_high : v_low) : v_low, 0, trise);
	V(in1[16]) <+ transition(($abstime >= 19n + T_dur && $abstime < 19n + Twrite_dur) ?
                    ((row19_value_left >> 16) & 1 ? v_high : v_low) : v_low, 0, trise);
	V(in2[16]) <+ transition(($abstime >= 19n + T_dur && $abstime < 19n + Twrite_dur) ?
                    ((row19_value_right >> 16) & 1 ? v_high : v_low) : v_low, 0, trise);
	V(in1[17]) <+ transition(($abstime >= 19n + T_dur && $abstime < 19n + Twrite_dur) ?
                    ((row19_value_left >> 17) & 1 ? v_high : v_low) : v_low, 0, trise);
	V(in2[17]) <+ transition(($abstime >= 19n + T_dur && $abstime < 19n + Twrite_dur) ?
                    ((row19_value_right >> 17) & 1 ? v_high : v_low) : v_low, 0, trise);
	V(in1[18]) <+ transition(($abstime >= 19n + T_dur && $abstime < 19n + Twrite_dur) ?
                    ((row19_value_left >> 18) & 1 ? v_high : v_low) : v_low, 0, trise);
	V(in2[18]) <+ transition(($abstime >= 19n + T_dur && $abstime < 19n + Twrite_dur) ?
                    ((row19_value_right >> 18) & 1 ? v_high : v_low) : v_low, 0, trise);
	V(in1[19]) <+ transition(($abstime >= 19n + T_dur && $abstime < 19n + Twrite_dur) ?
                    ((row19_value_left >> 19) & 1 ? v_high : v_low) : v_low, 0, trise);
	V(in2[19]) <+ transition(($abstime >= 19n + T_dur && $abstime < 19n + Twrite_dur) ?
                    ((row19_value_right >> 19) & 1 ? v_high : v_low) : v_low, 0, trise);
	V(in1[20]) <+ transition(($abstime >= 19n + T_dur && $abstime < 19n + Twrite_dur) ?
                    ((row19_value_left >> 20) & 1 ? v_high : v_low) : v_low, 0, trise);
	V(in2[20]) <+ transition(($abstime >= 19n + T_dur && $abstime < 19n + Twrite_dur) ?
                    ((row19_value_right >> 20) & 1 ? v_high : v_low) : v_low, 0, trise);
	V(in1[21]) <+ transition(($abstime >= 19n + T_dur && $abstime < 19n + Twrite_dur) ?
                    ((row19_value_left >> 21) & 1 ? v_high : v_low) : v_low, 0, trise);
	V(in2[21]) <+ transition(($abstime >= 19n + T_dur && $abstime < 19n + Twrite_dur) ?
                    ((row19_value_right >> 21) & 1 ? v_high : v_low) : v_low, 0, trise);
	V(in1[22]) <+ transition(($abstime >= 19n + T_dur && $abstime < 19n + Twrite_dur) ?
                    ((row19_value_left >> 22) & 1 ? v_high : v_low) : v_low, 0, trise);
	V(in2[22]) <+ transition(($abstime >= 19n + T_dur && $abstime < 19n + Twrite_dur) ?
                    ((row19_value_right >> 22) & 1 ? v_high : v_low) : v_low, 0, trise);
	V(in1[23]) <+ transition(($abstime >= 19n + T_dur && $abstime < 19n + Twrite_dur) ?
                    ((row19_value_left >> 23) & 1 ? v_high : v_low) : v_low, 0, trise);
	V(in2[23]) <+ transition(($abstime >= 19n + T_dur && $abstime < 19n + Twrite_dur) ?
                    ((row19_value_right >> 23) & 1 ? v_high : v_low) : v_low, 0, trise);
	V(in1[24]) <+ transition(($abstime >= 19n + T_dur && $abstime < 19n + Twrite_dur) ?
                    ((row19_value_left >> 24) & 1 ? v_high : v_low) : v_low, 0, trise);
	V(in2[24]) <+ transition(($abstime >= 19n + T_dur && $abstime < 19n + Twrite_dur) ?
                    ((row19_value_right >> 24) & 1 ? v_high : v_low) : v_low, 0, trise);
	V(in1[25]) <+ transition(($abstime >= 19n + T_dur && $abstime < 19n + Twrite_dur) ?
                    ((row19_value_left >> 25) & 1 ? v_high : v_low) : v_low, 0, trise);
	V(in2[25]) <+ transition(($abstime >= 19n + T_dur && $abstime < 19n + Twrite_dur) ?
                    ((row19_value_right >> 25) & 1 ? v_high : v_low) : v_low, 0, trise);
	V(in1[26]) <+ transition(($abstime >= 19n + T_dur && $abstime < 19n + Twrite_dur) ?
                    ((row19_value_left >> 26) & 1 ? v_high : v_low) : v_low, 0, trise);
	V(in2[26]) <+ transition(($abstime >= 19n + T_dur && $abstime < 19n + Twrite_dur) ?
                    ((row19_value_right >> 26) & 1 ? v_high : v_low) : v_low, 0, trise);
	V(in1[27]) <+ transition(($abstime >= 19n + T_dur && $abstime < 19n + Twrite_dur) ?
                    ((row19_value_left >> 27) & 1 ? v_high : v_low) : v_low, 0, trise);
	V(in2[27]) <+ transition(($abstime >= 19n + T_dur && $abstime < 19n + Twrite_dur) ?
                    ((row19_value_right >> 27) & 1 ? v_high : v_low) : v_low, 0, trise);
	V(in1[28]) <+ transition(($abstime >= 19n + T_dur && $abstime < 19n + Twrite_dur) ?
                    ((row19_value_left >> 28) & 1 ? v_high : v_low) : v_low, 0, trise);
	V(in2[28]) <+ transition(($abstime >= 19n + T_dur && $abstime < 19n + Twrite_dur) ?
                    ((row19_value_right >> 28) & 1 ? v_high : v_low) : v_low, 0, trise);
	V(in1[29]) <+ transition(($abstime >= 19n + T_dur && $abstime < 19n + Twrite_dur) ?
                    ((row19_value_left >> 29) & 1 ? v_high : v_low) : v_low, 0, trise);
	V(in2[29]) <+ transition(($abstime >= 19n + T_dur && $abstime < 19n + Twrite_dur) ?
                    ((row19_value_right >> 29) & 1 ? v_high : v_low) : v_low, 0, trise);
	V(in1[30]) <+ transition(($abstime >= 19n + T_dur && $abstime < 19n + Twrite_dur) ?
                    ((row19_value_left >> 30) & 1 ? v_high : v_low) : v_low, 0, trise);
	V(in2[30]) <+ transition(($abstime >= 19n + T_dur && $abstime < 19n + Twrite_dur) ?
                    ((row19_value_right >> 30) & 1 ? v_high : v_low) : v_low, 0, trise);
	V(in1[31]) <+ transition(($abstime >= 19n + T_dur && $abstime < 19n + Twrite_dur) ?
                    ((row19_value_left >> 31) & 1 ? v_high : v_low) : v_low, 0, trise);
	V(in2[31]) <+ transition(($abstime >= 19n + T_dur && $abstime < 19n + Twrite_dur) ?
                    ((row19_value_right >> 31) & 1 ? v_high : v_low) : v_low, 0, trise);

    V(write) <+ transition(($abstime >= 20n + T_dur && $abstime < 20n + Twrite_dur) ? v_high : v_low, 0, trise);
    V(WL[20]) <+ transition(($abstime >= 20n + T_dur && $abstime < 20n + TWL_dur) ? v_high : v_low, 0, trise);
	V(in1[0]) <+ transition(($abstime >= 20n + T_dur && $abstime < 20n + Twrite_dur) ?
                    ((row20_value_left >> 0) & 1 ? v_high : v_low) : v_low, 0, trise);
	V(in2[0]) <+ transition(($abstime >= 20n + T_dur && $abstime < 20n + Twrite_dur) ?
                    ((row20_value_right >> 0) & 1 ? v_high : v_low) : v_low, 0, trise);
	V(in1[1]) <+ transition(($abstime >= 20n + T_dur && $abstime < 20n + Twrite_dur) ?
                    ((row20_value_left >> 1) & 1 ? v_high : v_low) : v_low, 0, trise);
	V(in2[1]) <+ transition(($abstime >= 20n + T_dur && $abstime < 20n + Twrite_dur) ?
                    ((row20_value_right >> 1) & 1 ? v_high : v_low) : v_low, 0, trise);
	V(in1[2]) <+ transition(($abstime >= 20n + T_dur && $abstime < 20n + Twrite_dur) ?
                    ((row20_value_left >> 2) & 1 ? v_high : v_low) : v_low, 0, trise);
	V(in2[2]) <+ transition(($abstime >= 20n + T_dur && $abstime < 20n + Twrite_dur) ?
                    ((row20_value_right >> 2) & 1 ? v_high : v_low) : v_low, 0, trise);
	V(in1[3]) <+ transition(($abstime >= 20n + T_dur && $abstime < 20n + Twrite_dur) ?
                    ((row20_value_left >> 3) & 1 ? v_high : v_low) : v_low, 0, trise);
	V(in2[3]) <+ transition(($abstime >= 20n + T_dur && $abstime < 20n + Twrite_dur) ?
                    ((row20_value_right >> 3) & 1 ? v_high : v_low) : v_low, 0, trise);
	V(in1[4]) <+ transition(($abstime >= 20n + T_dur && $abstime < 20n + Twrite_dur) ?
                    ((row20_value_left >> 4) & 1 ? v_high : v_low) : v_low, 0, trise);
	V(in2[4]) <+ transition(($abstime >= 20n + T_dur && $abstime < 20n + Twrite_dur) ?
                    ((row20_value_right >> 4) & 1 ? v_high : v_low) : v_low, 0, trise);
	V(in1[5]) <+ transition(($abstime >= 20n + T_dur && $abstime < 20n + Twrite_dur) ?
                    ((row20_value_left >> 5) & 1 ? v_high : v_low) : v_low, 0, trise);
	V(in2[5]) <+ transition(($abstime >= 20n + T_dur && $abstime < 20n + Twrite_dur) ?
                    ((row20_value_right >> 5) & 1 ? v_high : v_low) : v_low, 0, trise);
	V(in1[6]) <+ transition(($abstime >= 20n + T_dur && $abstime < 20n + Twrite_dur) ?
                    ((row20_value_left >> 6) & 1 ? v_high : v_low) : v_low, 0, trise);
	V(in2[6]) <+ transition(($abstime >= 20n + T_dur && $abstime < 20n + Twrite_dur) ?
                    ((row20_value_right >> 6) & 1 ? v_high : v_low) : v_low, 0, trise);
	V(in1[7]) <+ transition(($abstime >= 20n + T_dur && $abstime < 20n + Twrite_dur) ?
                    ((row20_value_left >> 7) & 1 ? v_high : v_low) : v_low, 0, trise);
	V(in2[7]) <+ transition(($abstime >= 20n + T_dur && $abstime < 20n + Twrite_dur) ?
                    ((row20_value_right >> 7) & 1 ? v_high : v_low) : v_low, 0, trise);
	V(in1[8]) <+ transition(($abstime >= 20n + T_dur && $abstime < 20n + Twrite_dur) ?
                    ((row20_value_left >> 8) & 1 ? v_high : v_low) : v_low, 0, trise);
	V(in2[8]) <+ transition(($abstime >= 20n + T_dur && $abstime < 20n + Twrite_dur) ?
                    ((row20_value_right >> 8) & 1 ? v_high : v_low) : v_low, 0, trise);
	V(in1[9]) <+ transition(($abstime >= 20n + T_dur && $abstime < 20n + Twrite_dur) ?
                    ((row20_value_left >> 9) & 1 ? v_high : v_low) : v_low, 0, trise);
	V(in2[9]) <+ transition(($abstime >= 20n + T_dur && $abstime < 20n + Twrite_dur) ?
                    ((row20_value_right >> 9) & 1 ? v_high : v_low) : v_low, 0, trise);
	V(in1[10]) <+ transition(($abstime >= 20n + T_dur && $abstime < 20n + Twrite_dur) ?
                    ((row20_value_left >> 10) & 1 ? v_high : v_low) : v_low, 0, trise);
	V(in2[10]) <+ transition(($abstime >= 20n + T_dur && $abstime < 20n + Twrite_dur) ?
                    ((row20_value_right >> 10) & 1 ? v_high : v_low) : v_low, 0, trise);
	V(in1[11]) <+ transition(($abstime >= 20n + T_dur && $abstime < 20n + Twrite_dur) ?
                    ((row20_value_left >> 11) & 1 ? v_high : v_low) : v_low, 0, trise);
	V(in2[11]) <+ transition(($abstime >= 20n + T_dur && $abstime < 20n + Twrite_dur) ?
                    ((row20_value_right >> 11) & 1 ? v_high : v_low) : v_low, 0, trise);
	V(in1[12]) <+ transition(($abstime >= 20n + T_dur && $abstime < 20n + Twrite_dur) ?
                    ((row20_value_left >> 12) & 1 ? v_high : v_low) : v_low, 0, trise);
	V(in2[12]) <+ transition(($abstime >= 20n + T_dur && $abstime < 20n + Twrite_dur) ?
                    ((row20_value_right >> 12) & 1 ? v_high : v_low) : v_low, 0, trise);
	V(in1[13]) <+ transition(($abstime >= 20n + T_dur && $abstime < 20n + Twrite_dur) ?
                    ((row20_value_left >> 13) & 1 ? v_high : v_low) : v_low, 0, trise);
	V(in2[13]) <+ transition(($abstime >= 20n + T_dur && $abstime < 20n + Twrite_dur) ?
                    ((row20_value_right >> 13) & 1 ? v_high : v_low) : v_low, 0, trise);
	V(in1[14]) <+ transition(($abstime >= 20n + T_dur && $abstime < 20n + Twrite_dur) ?
                    ((row20_value_left >> 14) & 1 ? v_high : v_low) : v_low, 0, trise);
	V(in2[14]) <+ transition(($abstime >= 20n + T_dur && $abstime < 20n + Twrite_dur) ?
                    ((row20_value_right >> 14) & 1 ? v_high : v_low) : v_low, 0, trise);
	V(in1[15]) <+ transition(($abstime >= 20n + T_dur && $abstime < 20n + Twrite_dur) ?
                    ((row20_value_left >> 15) & 1 ? v_high : v_low) : v_low, 0, trise);
	V(in2[15]) <+ transition(($abstime >= 20n + T_dur && $abstime < 20n + Twrite_dur) ?
                    ((row20_value_right >> 15) & 1 ? v_high : v_low) : v_low, 0, trise);
	V(in1[16]) <+ transition(($abstime >= 20n + T_dur && $abstime < 20n + Twrite_dur) ?
                    ((row20_value_left >> 16) & 1 ? v_high : v_low) : v_low, 0, trise);
	V(in2[16]) <+ transition(($abstime >= 20n + T_dur && $abstime < 20n + Twrite_dur) ?
                    ((row20_value_right >> 16) & 1 ? v_high : v_low) : v_low, 0, trise);
	V(in1[17]) <+ transition(($abstime >= 20n + T_dur && $abstime < 20n + Twrite_dur) ?
                    ((row20_value_left >> 17) & 1 ? v_high : v_low) : v_low, 0, trise);
	V(in2[17]) <+ transition(($abstime >= 20n + T_dur && $abstime < 20n + Twrite_dur) ?
                    ((row20_value_right >> 17) & 1 ? v_high : v_low) : v_low, 0, trise);
	V(in1[18]) <+ transition(($abstime >= 20n + T_dur && $abstime < 20n + Twrite_dur) ?
                    ((row20_value_left >> 18) & 1 ? v_high : v_low) : v_low, 0, trise);
	V(in2[18]) <+ transition(($abstime >= 20n + T_dur && $abstime < 20n + Twrite_dur) ?
                    ((row20_value_right >> 18) & 1 ? v_high : v_low) : v_low, 0, trise);
	V(in1[19]) <+ transition(($abstime >= 20n + T_dur && $abstime < 20n + Twrite_dur) ?
                    ((row20_value_left >> 19) & 1 ? v_high : v_low) : v_low, 0, trise);
	V(in2[19]) <+ transition(($abstime >= 20n + T_dur && $abstime < 20n + Twrite_dur) ?
                    ((row20_value_right >> 19) & 1 ? v_high : v_low) : v_low, 0, trise);
	V(in1[20]) <+ transition(($abstime >= 20n + T_dur && $abstime < 20n + Twrite_dur) ?
                    ((row20_value_left >> 20) & 1 ? v_high : v_low) : v_low, 0, trise);
	V(in2[20]) <+ transition(($abstime >= 20n + T_dur && $abstime < 20n + Twrite_dur) ?
                    ((row20_value_right >> 20) & 1 ? v_high : v_low) : v_low, 0, trise);
	V(in1[21]) <+ transition(($abstime >= 20n + T_dur && $abstime < 20n + Twrite_dur) ?
                    ((row20_value_left >> 21) & 1 ? v_high : v_low) : v_low, 0, trise);
	V(in2[21]) <+ transition(($abstime >= 20n + T_dur && $abstime < 20n + Twrite_dur) ?
                    ((row20_value_right >> 21) & 1 ? v_high : v_low) : v_low, 0, trise);
	V(in1[22]) <+ transition(($abstime >= 20n + T_dur && $abstime < 20n + Twrite_dur) ?
                    ((row20_value_left >> 22) & 1 ? v_high : v_low) : v_low, 0, trise);
	V(in2[22]) <+ transition(($abstime >= 20n + T_dur && $abstime < 20n + Twrite_dur) ?
                    ((row20_value_right >> 22) & 1 ? v_high : v_low) : v_low, 0, trise);
	V(in1[23]) <+ transition(($abstime >= 20n + T_dur && $abstime < 20n + Twrite_dur) ?
                    ((row20_value_left >> 23) & 1 ? v_high : v_low) : v_low, 0, trise);
	V(in2[23]) <+ transition(($abstime >= 20n + T_dur && $abstime < 20n + Twrite_dur) ?
                    ((row20_value_right >> 23) & 1 ? v_high : v_low) : v_low, 0, trise);
	V(in1[24]) <+ transition(($abstime >= 20n + T_dur && $abstime < 20n + Twrite_dur) ?
                    ((row20_value_left >> 24) & 1 ? v_high : v_low) : v_low, 0, trise);
	V(in2[24]) <+ transition(($abstime >= 20n + T_dur && $abstime < 20n + Twrite_dur) ?
                    ((row20_value_right >> 24) & 1 ? v_high : v_low) : v_low, 0, trise);
	V(in1[25]) <+ transition(($abstime >= 20n + T_dur && $abstime < 20n + Twrite_dur) ?
                    ((row20_value_left >> 25) & 1 ? v_high : v_low) : v_low, 0, trise);
	V(in2[25]) <+ transition(($abstime >= 20n + T_dur && $abstime < 20n + Twrite_dur) ?
                    ((row20_value_right >> 25) & 1 ? v_high : v_low) : v_low, 0, trise);
	V(in1[26]) <+ transition(($abstime >= 20n + T_dur && $abstime < 20n + Twrite_dur) ?
                    ((row20_value_left >> 26) & 1 ? v_high : v_low) : v_low, 0, trise);
	V(in2[26]) <+ transition(($abstime >= 20n + T_dur && $abstime < 20n + Twrite_dur) ?
                    ((row20_value_right >> 26) & 1 ? v_high : v_low) : v_low, 0, trise);
	V(in1[27]) <+ transition(($abstime >= 20n + T_dur && $abstime < 20n + Twrite_dur) ?
                    ((row20_value_left >> 27) & 1 ? v_high : v_low) : v_low, 0, trise);
	V(in2[27]) <+ transition(($abstime >= 20n + T_dur && $abstime < 20n + Twrite_dur) ?
                    ((row20_value_right >> 27) & 1 ? v_high : v_low) : v_low, 0, trise);
	V(in1[28]) <+ transition(($abstime >= 20n + T_dur && $abstime < 20n + Twrite_dur) ?
                    ((row20_value_left >> 28) & 1 ? v_high : v_low) : v_low, 0, trise);
	V(in2[28]) <+ transition(($abstime >= 20n + T_dur && $abstime < 20n + Twrite_dur) ?
                    ((row20_value_right >> 28) & 1 ? v_high : v_low) : v_low, 0, trise);
	V(in1[29]) <+ transition(($abstime >= 20n + T_dur && $abstime < 20n + Twrite_dur) ?
                    ((row20_value_left >> 29) & 1 ? v_high : v_low) : v_low, 0, trise);
	V(in2[29]) <+ transition(($abstime >= 20n + T_dur && $abstime < 20n + Twrite_dur) ?
                    ((row20_value_right >> 29) & 1 ? v_high : v_low) : v_low, 0, trise);
	V(in1[30]) <+ transition(($abstime >= 20n + T_dur && $abstime < 20n + Twrite_dur) ?
                    ((row20_value_left >> 30) & 1 ? v_high : v_low) : v_low, 0, trise);
	V(in2[30]) <+ transition(($abstime >= 20n + T_dur && $abstime < 20n + Twrite_dur) ?
                    ((row20_value_right >> 30) & 1 ? v_high : v_low) : v_low, 0, trise);
	V(in1[31]) <+ transition(($abstime >= 20n + T_dur && $abstime < 20n + Twrite_dur) ?
                    ((row20_value_left >> 31) & 1 ? v_high : v_low) : v_low, 0, trise);
	V(in2[31]) <+ transition(($abstime >= 20n + T_dur && $abstime < 20n + Twrite_dur) ?
                    ((row20_value_right >> 31) & 1 ? v_high : v_low) : v_low, 0, trise);

    V(write) <+ transition(($abstime >= 21n + T_dur && $abstime < 21n + Twrite_dur) ? v_high : v_low, 0, trise);
    V(WL[21]) <+ transition(($abstime >= 21n + T_dur && $abstime < 21n + TWL_dur) ? v_high : v_low, 0, trise);
	V(in1[0]) <+ transition(($abstime >= 21n + T_dur && $abstime < 21n + Twrite_dur) ?
                    ((row21_value_left >> 0) & 1 ? v_high : v_low) : v_low, 0, trise);
	V(in2[0]) <+ transition(($abstime >= 21n + T_dur && $abstime < 21n + Twrite_dur) ?
                    ((row21_value_right >> 0) & 1 ? v_high : v_low) : v_low, 0, trise);
	V(in1[1]) <+ transition(($abstime >= 21n + T_dur && $abstime < 21n + Twrite_dur) ?
                    ((row21_value_left >> 1) & 1 ? v_high : v_low) : v_low, 0, trise);
	V(in2[1]) <+ transition(($abstime >= 21n + T_dur && $abstime < 21n + Twrite_dur) ?
                    ((row21_value_right >> 1) & 1 ? v_high : v_low) : v_low, 0, trise);
	V(in1[2]) <+ transition(($abstime >= 21n + T_dur && $abstime < 21n + Twrite_dur) ?
                    ((row21_value_left >> 2) & 1 ? v_high : v_low) : v_low, 0, trise);
	V(in2[2]) <+ transition(($abstime >= 21n + T_dur && $abstime < 21n + Twrite_dur) ?
                    ((row21_value_right >> 2) & 1 ? v_high : v_low) : v_low, 0, trise);
	V(in1[3]) <+ transition(($abstime >= 21n + T_dur && $abstime < 21n + Twrite_dur) ?
                    ((row21_value_left >> 3) & 1 ? v_high : v_low) : v_low, 0, trise);
	V(in2[3]) <+ transition(($abstime >= 21n + T_dur && $abstime < 21n + Twrite_dur) ?
                    ((row21_value_right >> 3) & 1 ? v_high : v_low) : v_low, 0, trise);
	V(in1[4]) <+ transition(($abstime >= 21n + T_dur && $abstime < 21n + Twrite_dur) ?
                    ((row21_value_left >> 4) & 1 ? v_high : v_low) : v_low, 0, trise);
	V(in2[4]) <+ transition(($abstime >= 21n + T_dur && $abstime < 21n + Twrite_dur) ?
                    ((row21_value_right >> 4) & 1 ? v_high : v_low) : v_low, 0, trise);
	V(in1[5]) <+ transition(($abstime >= 21n + T_dur && $abstime < 21n + Twrite_dur) ?
                    ((row21_value_left >> 5) & 1 ? v_high : v_low) : v_low, 0, trise);
	V(in2[5]) <+ transition(($abstime >= 21n + T_dur && $abstime < 21n + Twrite_dur) ?
                    ((row21_value_right >> 5) & 1 ? v_high : v_low) : v_low, 0, trise);
	V(in1[6]) <+ transition(($abstime >= 21n + T_dur && $abstime < 21n + Twrite_dur) ?
                    ((row21_value_left >> 6) & 1 ? v_high : v_low) : v_low, 0, trise);
	V(in2[6]) <+ transition(($abstime >= 21n + T_dur && $abstime < 21n + Twrite_dur) ?
                    ((row21_value_right >> 6) & 1 ? v_high : v_low) : v_low, 0, trise);
	V(in1[7]) <+ transition(($abstime >= 21n + T_dur && $abstime < 21n + Twrite_dur) ?
                    ((row21_value_left >> 7) & 1 ? v_high : v_low) : v_low, 0, trise);
	V(in2[7]) <+ transition(($abstime >= 21n + T_dur && $abstime < 21n + Twrite_dur) ?
                    ((row21_value_right >> 7) & 1 ? v_high : v_low) : v_low, 0, trise);
	V(in1[8]) <+ transition(($abstime >= 21n + T_dur && $abstime < 21n + Twrite_dur) ?
                    ((row21_value_left >> 8) & 1 ? v_high : v_low) : v_low, 0, trise);
	V(in2[8]) <+ transition(($abstime >= 21n + T_dur && $abstime < 21n + Twrite_dur) ?
                    ((row21_value_right >> 8) & 1 ? v_high : v_low) : v_low, 0, trise);
	V(in1[9]) <+ transition(($abstime >= 21n + T_dur && $abstime < 21n + Twrite_dur) ?
                    ((row21_value_left >> 9) & 1 ? v_high : v_low) : v_low, 0, trise);
	V(in2[9]) <+ transition(($abstime >= 21n + T_dur && $abstime < 21n + Twrite_dur) ?
                    ((row21_value_right >> 9) & 1 ? v_high : v_low) : v_low, 0, trise);
	V(in1[10]) <+ transition(($abstime >= 21n + T_dur && $abstime < 21n + Twrite_dur) ?
                    ((row21_value_left >> 10) & 1 ? v_high : v_low) : v_low, 0, trise);
	V(in2[10]) <+ transition(($abstime >= 21n + T_dur && $abstime < 21n + Twrite_dur) ?
                    ((row21_value_right >> 10) & 1 ? v_high : v_low) : v_low, 0, trise);
	V(in1[11]) <+ transition(($abstime >= 21n + T_dur && $abstime < 21n + Twrite_dur) ?
                    ((row21_value_left >> 11) & 1 ? v_high : v_low) : v_low, 0, trise);
	V(in2[11]) <+ transition(($abstime >= 21n + T_dur && $abstime < 21n + Twrite_dur) ?
                    ((row21_value_right >> 11) & 1 ? v_high : v_low) : v_low, 0, trise);
	V(in1[12]) <+ transition(($abstime >= 21n + T_dur && $abstime < 21n + Twrite_dur) ?
                    ((row21_value_left >> 12) & 1 ? v_high : v_low) : v_low, 0, trise);
	V(in2[12]) <+ transition(($abstime >= 21n + T_dur && $abstime < 21n + Twrite_dur) ?
                    ((row21_value_right >> 12) & 1 ? v_high : v_low) : v_low, 0, trise);
	V(in1[13]) <+ transition(($abstime >= 21n + T_dur && $abstime < 21n + Twrite_dur) ?
                    ((row21_value_left >> 13) & 1 ? v_high : v_low) : v_low, 0, trise);
	V(in2[13]) <+ transition(($abstime >= 21n + T_dur && $abstime < 21n + Twrite_dur) ?
                    ((row21_value_right >> 13) & 1 ? v_high : v_low) : v_low, 0, trise);
	V(in1[14]) <+ transition(($abstime >= 21n + T_dur && $abstime < 21n + Twrite_dur) ?
                    ((row21_value_left >> 14) & 1 ? v_high : v_low) : v_low, 0, trise);
	V(in2[14]) <+ transition(($abstime >= 21n + T_dur && $abstime < 21n + Twrite_dur) ?
                    ((row21_value_right >> 14) & 1 ? v_high : v_low) : v_low, 0, trise);
	V(in1[15]) <+ transition(($abstime >= 21n + T_dur && $abstime < 21n + Twrite_dur) ?
                    ((row21_value_left >> 15) & 1 ? v_high : v_low) : v_low, 0, trise);
	V(in2[15]) <+ transition(($abstime >= 21n + T_dur && $abstime < 21n + Twrite_dur) ?
                    ((row21_value_right >> 15) & 1 ? v_high : v_low) : v_low, 0, trise);
	V(in1[16]) <+ transition(($abstime >= 21n + T_dur && $abstime < 21n + Twrite_dur) ?
                    ((row21_value_left >> 16) & 1 ? v_high : v_low) : v_low, 0, trise);
	V(in2[16]) <+ transition(($abstime >= 21n + T_dur && $abstime < 21n + Twrite_dur) ?
                    ((row21_value_right >> 16) & 1 ? v_high : v_low) : v_low, 0, trise);
	V(in1[17]) <+ transition(($abstime >= 21n + T_dur && $abstime < 21n + Twrite_dur) ?
                    ((row21_value_left >> 17) & 1 ? v_high : v_low) : v_low, 0, trise);
	V(in2[17]) <+ transition(($abstime >= 21n + T_dur && $abstime < 21n + Twrite_dur) ?
                    ((row21_value_right >> 17) & 1 ? v_high : v_low) : v_low, 0, trise);
	V(in1[18]) <+ transition(($abstime >= 21n + T_dur && $abstime < 21n + Twrite_dur) ?
                    ((row21_value_left >> 18) & 1 ? v_high : v_low) : v_low, 0, trise);
	V(in2[18]) <+ transition(($abstime >= 21n + T_dur && $abstime < 21n + Twrite_dur) ?
                    ((row21_value_right >> 18) & 1 ? v_high : v_low) : v_low, 0, trise);
	V(in1[19]) <+ transition(($abstime >= 21n + T_dur && $abstime < 21n + Twrite_dur) ?
                    ((row21_value_left >> 19) & 1 ? v_high : v_low) : v_low, 0, trise);
	V(in2[19]) <+ transition(($abstime >= 21n + T_dur && $abstime < 21n + Twrite_dur) ?
                    ((row21_value_right >> 19) & 1 ? v_high : v_low) : v_low, 0, trise);
	V(in1[20]) <+ transition(($abstime >= 21n + T_dur && $abstime < 21n + Twrite_dur) ?
                    ((row21_value_left >> 20) & 1 ? v_high : v_low) : v_low, 0, trise);
	V(in2[20]) <+ transition(($abstime >= 21n + T_dur && $abstime < 21n + Twrite_dur) ?
                    ((row21_value_right >> 20) & 1 ? v_high : v_low) : v_low, 0, trise);
	V(in1[21]) <+ transition(($abstime >= 21n + T_dur && $abstime < 21n + Twrite_dur) ?
                    ((row21_value_left >> 21) & 1 ? v_high : v_low) : v_low, 0, trise);
	V(in2[21]) <+ transition(($abstime >= 21n + T_dur && $abstime < 21n + Twrite_dur) ?
                    ((row21_value_right >> 21) & 1 ? v_high : v_low) : v_low, 0, trise);
	V(in1[22]) <+ transition(($abstime >= 21n + T_dur && $abstime < 21n + Twrite_dur) ?
                    ((row21_value_left >> 22) & 1 ? v_high : v_low) : v_low, 0, trise);
	V(in2[22]) <+ transition(($abstime >= 21n + T_dur && $abstime < 21n + Twrite_dur) ?
                    ((row21_value_right >> 22) & 1 ? v_high : v_low) : v_low, 0, trise);
	V(in1[23]) <+ transition(($abstime >= 21n + T_dur && $abstime < 21n + Twrite_dur) ?
                    ((row21_value_left >> 23) & 1 ? v_high : v_low) : v_low, 0, trise);
	V(in2[23]) <+ transition(($abstime >= 21n + T_dur && $abstime < 21n + Twrite_dur) ?
                    ((row21_value_right >> 23) & 1 ? v_high : v_low) : v_low, 0, trise);
	V(in1[24]) <+ transition(($abstime >= 21n + T_dur && $abstime < 21n + Twrite_dur) ?
                    ((row21_value_left >> 24) & 1 ? v_high : v_low) : v_low, 0, trise);
	V(in2[24]) <+ transition(($abstime >= 21n + T_dur && $abstime < 21n + Twrite_dur) ?
                    ((row21_value_right >> 24) & 1 ? v_high : v_low) : v_low, 0, trise);
	V(in1[25]) <+ transition(($abstime >= 21n + T_dur && $abstime < 21n + Twrite_dur) ?
                    ((row21_value_left >> 25) & 1 ? v_high : v_low) : v_low, 0, trise);
	V(in2[25]) <+ transition(($abstime >= 21n + T_dur && $abstime < 21n + Twrite_dur) ?
                    ((row21_value_right >> 25) & 1 ? v_high : v_low) : v_low, 0, trise);
	V(in1[26]) <+ transition(($abstime >= 21n + T_dur && $abstime < 21n + Twrite_dur) ?
                    ((row21_value_left >> 26) & 1 ? v_high : v_low) : v_low, 0, trise);
	V(in2[26]) <+ transition(($abstime >= 21n + T_dur && $abstime < 21n + Twrite_dur) ?
                    ((row21_value_right >> 26) & 1 ? v_high : v_low) : v_low, 0, trise);
	V(in1[27]) <+ transition(($abstime >= 21n + T_dur && $abstime < 21n + Twrite_dur) ?
                    ((row21_value_left >> 27) & 1 ? v_high : v_low) : v_low, 0, trise);
	V(in2[27]) <+ transition(($abstime >= 21n + T_dur && $abstime < 21n + Twrite_dur) ?
                    ((row21_value_right >> 27) & 1 ? v_high : v_low) : v_low, 0, trise);
	V(in1[28]) <+ transition(($abstime >= 21n + T_dur && $abstime < 21n + Twrite_dur) ?
                    ((row21_value_left >> 28) & 1 ? v_high : v_low) : v_low, 0, trise);
	V(in2[28]) <+ transition(($abstime >= 21n + T_dur && $abstime < 21n + Twrite_dur) ?
                    ((row21_value_right >> 28) & 1 ? v_high : v_low) : v_low, 0, trise);
	V(in1[29]) <+ transition(($abstime >= 21n + T_dur && $abstime < 21n + Twrite_dur) ?
                    ((row21_value_left >> 29) & 1 ? v_high : v_low) : v_low, 0, trise);
	V(in2[29]) <+ transition(($abstime >= 21n + T_dur && $abstime < 21n + Twrite_dur) ?
                    ((row21_value_right >> 29) & 1 ? v_high : v_low) : v_low, 0, trise);
	V(in1[30]) <+ transition(($abstime >= 21n + T_dur && $abstime < 21n + Twrite_dur) ?
                    ((row21_value_left >> 30) & 1 ? v_high : v_low) : v_low, 0, trise);
	V(in2[30]) <+ transition(($abstime >= 21n + T_dur && $abstime < 21n + Twrite_dur) ?
                    ((row21_value_right >> 30) & 1 ? v_high : v_low) : v_low, 0, trise);
	V(in1[31]) <+ transition(($abstime >= 21n + T_dur && $abstime < 21n + Twrite_dur) ?
                    ((row21_value_left >> 31) & 1 ? v_high : v_low) : v_low, 0, trise);
	V(in2[31]) <+ transition(($abstime >= 21n + T_dur && $abstime < 21n + Twrite_dur) ?
                    ((row21_value_right >> 31) & 1 ? v_high : v_low) : v_low, 0, trise);

    V(write) <+ transition(($abstime >= 22n + T_dur && $abstime < 22n + Twrite_dur) ? v_high : v_low, 0, trise);
    V(WL[22]) <+ transition(($abstime >= 22n + T_dur && $abstime < 22n + TWL_dur) ? v_high : v_low, 0, trise);
	V(in1[0]) <+ transition(($abstime >= 22n + T_dur && $abstime < 22n + Twrite_dur) ?
                    ((row22_value_left >> 0) & 1 ? v_high : v_low) : v_low, 0, trise);
	V(in2[0]) <+ transition(($abstime >= 22n + T_dur && $abstime < 22n + Twrite_dur) ?
                    ((row22_value_right >> 0) & 1 ? v_high : v_low) : v_low, 0, trise);
	V(in1[1]) <+ transition(($abstime >= 22n + T_dur && $abstime < 22n + Twrite_dur) ?
                    ((row22_value_left >> 1) & 1 ? v_high : v_low) : v_low, 0, trise);
	V(in2[1]) <+ transition(($abstime >= 22n + T_dur && $abstime < 22n + Twrite_dur) ?
                    ((row22_value_right >> 1) & 1 ? v_high : v_low) : v_low, 0, trise);
	V(in1[2]) <+ transition(($abstime >= 22n + T_dur && $abstime < 22n + Twrite_dur) ?
                    ((row22_value_left >> 2) & 1 ? v_high : v_low) : v_low, 0, trise);
	V(in2[2]) <+ transition(($abstime >= 22n + T_dur && $abstime < 22n + Twrite_dur) ?
                    ((row22_value_right >> 2) & 1 ? v_high : v_low) : v_low, 0, trise);
	V(in1[3]) <+ transition(($abstime >= 22n + T_dur && $abstime < 22n + Twrite_dur) ?
                    ((row22_value_left >> 3) & 1 ? v_high : v_low) : v_low, 0, trise);
	V(in2[3]) <+ transition(($abstime >= 22n + T_dur && $abstime < 22n + Twrite_dur) ?
                    ((row22_value_right >> 3) & 1 ? v_high : v_low) : v_low, 0, trise);
	V(in1[4]) <+ transition(($abstime >= 22n + T_dur && $abstime < 22n + Twrite_dur) ?
                    ((row22_value_left >> 4) & 1 ? v_high : v_low) : v_low, 0, trise);
	V(in2[4]) <+ transition(($abstime >= 22n + T_dur && $abstime < 22n + Twrite_dur) ?
                    ((row22_value_right >> 4) & 1 ? v_high : v_low) : v_low, 0, trise);
	V(in1[5]) <+ transition(($abstime >= 22n + T_dur && $abstime < 22n + Twrite_dur) ?
                    ((row22_value_left >> 5) & 1 ? v_high : v_low) : v_low, 0, trise);
	V(in2[5]) <+ transition(($abstime >= 22n + T_dur && $abstime < 22n + Twrite_dur) ?
                    ((row22_value_right >> 5) & 1 ? v_high : v_low) : v_low, 0, trise);
	V(in1[6]) <+ transition(($abstime >= 22n + T_dur && $abstime < 22n + Twrite_dur) ?
                    ((row22_value_left >> 6) & 1 ? v_high : v_low) : v_low, 0, trise);
	V(in2[6]) <+ transition(($abstime >= 22n + T_dur && $abstime < 22n + Twrite_dur) ?
                    ((row22_value_right >> 6) & 1 ? v_high : v_low) : v_low, 0, trise);
	V(in1[7]) <+ transition(($abstime >= 22n + T_dur && $abstime < 22n + Twrite_dur) ?
                    ((row22_value_left >> 7) & 1 ? v_high : v_low) : v_low, 0, trise);
	V(in2[7]) <+ transition(($abstime >= 22n + T_dur && $abstime < 22n + Twrite_dur) ?
                    ((row22_value_right >> 7) & 1 ? v_high : v_low) : v_low, 0, trise);
	V(in1[8]) <+ transition(($abstime >= 22n + T_dur && $abstime < 22n + Twrite_dur) ?
                    ((row22_value_left >> 8) & 1 ? v_high : v_low) : v_low, 0, trise);
	V(in2[8]) <+ transition(($abstime >= 22n + T_dur && $abstime < 22n + Twrite_dur) ?
                    ((row22_value_right >> 8) & 1 ? v_high : v_low) : v_low, 0, trise);
	V(in1[9]) <+ transition(($abstime >= 22n + T_dur && $abstime < 22n + Twrite_dur) ?
                    ((row22_value_left >> 9) & 1 ? v_high : v_low) : v_low, 0, trise);
	V(in2[9]) <+ transition(($abstime >= 22n + T_dur && $abstime < 22n + Twrite_dur) ?
                    ((row22_value_right >> 9) & 1 ? v_high : v_low) : v_low, 0, trise);
	V(in1[10]) <+ transition(($abstime >= 22n + T_dur && $abstime < 22n + Twrite_dur) ?
                    ((row22_value_left >> 10) & 1 ? v_high : v_low) : v_low, 0, trise);
	V(in2[10]) <+ transition(($abstime >= 22n + T_dur && $abstime < 22n + Twrite_dur) ?
                    ((row22_value_right >> 10) & 1 ? v_high : v_low) : v_low, 0, trise);
	V(in1[11]) <+ transition(($abstime >= 22n + T_dur && $abstime < 22n + Twrite_dur) ?
                    ((row22_value_left >> 11) & 1 ? v_high : v_low) : v_low, 0, trise);
	V(in2[11]) <+ transition(($abstime >= 22n + T_dur && $abstime < 22n + Twrite_dur) ?
                    ((row22_value_right >> 11) & 1 ? v_high : v_low) : v_low, 0, trise);
	V(in1[12]) <+ transition(($abstime >= 22n + T_dur && $abstime < 22n + Twrite_dur) ?
                    ((row22_value_left >> 12) & 1 ? v_high : v_low) : v_low, 0, trise);
	V(in2[12]) <+ transition(($abstime >= 22n + T_dur && $abstime < 22n + Twrite_dur) ?
                    ((row22_value_right >> 12) & 1 ? v_high : v_low) : v_low, 0, trise);
	V(in1[13]) <+ transition(($abstime >= 22n + T_dur && $abstime < 22n + Twrite_dur) ?
                    ((row22_value_left >> 13) & 1 ? v_high : v_low) : v_low, 0, trise);
	V(in2[13]) <+ transition(($abstime >= 22n + T_dur && $abstime < 22n + Twrite_dur) ?
                    ((row22_value_right >> 13) & 1 ? v_high : v_low) : v_low, 0, trise);
	V(in1[14]) <+ transition(($abstime >= 22n + T_dur && $abstime < 22n + Twrite_dur) ?
                    ((row22_value_left >> 14) & 1 ? v_high : v_low) : v_low, 0, trise);
	V(in2[14]) <+ transition(($abstime >= 22n + T_dur && $abstime < 22n + Twrite_dur) ?
                    ((row22_value_right >> 14) & 1 ? v_high : v_low) : v_low, 0, trise);
	V(in1[15]) <+ transition(($abstime >= 22n + T_dur && $abstime < 22n + Twrite_dur) ?
                    ((row22_value_left >> 15) & 1 ? v_high : v_low) : v_low, 0, trise);
	V(in2[15]) <+ transition(($abstime >= 22n + T_dur && $abstime < 22n + Twrite_dur) ?
                    ((row22_value_right >> 15) & 1 ? v_high : v_low) : v_low, 0, trise);
	V(in1[16]) <+ transition(($abstime >= 22n + T_dur && $abstime < 22n + Twrite_dur) ?
                    ((row22_value_left >> 16) & 1 ? v_high : v_low) : v_low, 0, trise);
	V(in2[16]) <+ transition(($abstime >= 22n + T_dur && $abstime < 22n + Twrite_dur) ?
                    ((row22_value_right >> 16) & 1 ? v_high : v_low) : v_low, 0, trise);
	V(in1[17]) <+ transition(($abstime >= 22n + T_dur && $abstime < 22n + Twrite_dur) ?
                    ((row22_value_left >> 17) & 1 ? v_high : v_low) : v_low, 0, trise);
	V(in2[17]) <+ transition(($abstime >= 22n + T_dur && $abstime < 22n + Twrite_dur) ?
                    ((row22_value_right >> 17) & 1 ? v_high : v_low) : v_low, 0, trise);
	V(in1[18]) <+ transition(($abstime >= 22n + T_dur && $abstime < 22n + Twrite_dur) ?
                    ((row22_value_left >> 18) & 1 ? v_high : v_low) : v_low, 0, trise);
	V(in2[18]) <+ transition(($abstime >= 22n + T_dur && $abstime < 22n + Twrite_dur) ?
                    ((row22_value_right >> 18) & 1 ? v_high : v_low) : v_low, 0, trise);
	V(in1[19]) <+ transition(($abstime >= 22n + T_dur && $abstime < 22n + Twrite_dur) ?
                    ((row22_value_left >> 19) & 1 ? v_high : v_low) : v_low, 0, trise);
	V(in2[19]) <+ transition(($abstime >= 22n + T_dur && $abstime < 22n + Twrite_dur) ?
                    ((row22_value_right >> 19) & 1 ? v_high : v_low) : v_low, 0, trise);
	V(in1[20]) <+ transition(($abstime >= 22n + T_dur && $abstime < 22n + Twrite_dur) ?
                    ((row22_value_left >> 20) & 1 ? v_high : v_low) : v_low, 0, trise);
	V(in2[20]) <+ transition(($abstime >= 22n + T_dur && $abstime < 22n + Twrite_dur) ?
                    ((row22_value_right >> 20) & 1 ? v_high : v_low) : v_low, 0, trise);
	V(in1[21]) <+ transition(($abstime >= 22n + T_dur && $abstime < 22n + Twrite_dur) ?
                    ((row22_value_left >> 21) & 1 ? v_high : v_low) : v_low, 0, trise);
	V(in2[21]) <+ transition(($abstime >= 22n + T_dur && $abstime < 22n + Twrite_dur) ?
                    ((row22_value_right >> 21) & 1 ? v_high : v_low) : v_low, 0, trise);
	V(in1[22]) <+ transition(($abstime >= 22n + T_dur && $abstime < 22n + Twrite_dur) ?
                    ((row22_value_left >> 22) & 1 ? v_high : v_low) : v_low, 0, trise);
	V(in2[22]) <+ transition(($abstime >= 22n + T_dur && $abstime < 22n + Twrite_dur) ?
                    ((row22_value_right >> 22) & 1 ? v_high : v_low) : v_low, 0, trise);
	V(in1[23]) <+ transition(($abstime >= 22n + T_dur && $abstime < 22n + Twrite_dur) ?
                    ((row22_value_left >> 23) & 1 ? v_high : v_low) : v_low, 0, trise);
	V(in2[23]) <+ transition(($abstime >= 22n + T_dur && $abstime < 22n + Twrite_dur) ?
                    ((row22_value_right >> 23) & 1 ? v_high : v_low) : v_low, 0, trise);
	V(in1[24]) <+ transition(($abstime >= 22n + T_dur && $abstime < 22n + Twrite_dur) ?
                    ((row22_value_left >> 24) & 1 ? v_high : v_low) : v_low, 0, trise);
	V(in2[24]) <+ transition(($abstime >= 22n + T_dur && $abstime < 22n + Twrite_dur) ?
                    ((row22_value_right >> 24) & 1 ? v_high : v_low) : v_low, 0, trise);
	V(in1[25]) <+ transition(($abstime >= 22n + T_dur && $abstime < 22n + Twrite_dur) ?
                    ((row22_value_left >> 25) & 1 ? v_high : v_low) : v_low, 0, trise);
	V(in2[25]) <+ transition(($abstime >= 22n + T_dur && $abstime < 22n + Twrite_dur) ?
                    ((row22_value_right >> 25) & 1 ? v_high : v_low) : v_low, 0, trise);
	V(in1[26]) <+ transition(($abstime >= 22n + T_dur && $abstime < 22n + Twrite_dur) ?
                    ((row22_value_left >> 26) & 1 ? v_high : v_low) : v_low, 0, trise);
	V(in2[26]) <+ transition(($abstime >= 22n + T_dur && $abstime < 22n + Twrite_dur) ?
                    ((row22_value_right >> 26) & 1 ? v_high : v_low) : v_low, 0, trise);
	V(in1[27]) <+ transition(($abstime >= 22n + T_dur && $abstime < 22n + Twrite_dur) ?
                    ((row22_value_left >> 27) & 1 ? v_high : v_low) : v_low, 0, trise);
	V(in2[27]) <+ transition(($abstime >= 22n + T_dur && $abstime < 22n + Twrite_dur) ?
                    ((row22_value_right >> 27) & 1 ? v_high : v_low) : v_low, 0, trise);
	V(in1[28]) <+ transition(($abstime >= 22n + T_dur && $abstime < 22n + Twrite_dur) ?
                    ((row22_value_left >> 28) & 1 ? v_high : v_low) : v_low, 0, trise);
	V(in2[28]) <+ transition(($abstime >= 22n + T_dur && $abstime < 22n + Twrite_dur) ?
                    ((row22_value_right >> 28) & 1 ? v_high : v_low) : v_low, 0, trise);
	V(in1[29]) <+ transition(($abstime >= 22n + T_dur && $abstime < 22n + Twrite_dur) ?
                    ((row22_value_left >> 29) & 1 ? v_high : v_low) : v_low, 0, trise);
	V(in2[29]) <+ transition(($abstime >= 22n + T_dur && $abstime < 22n + Twrite_dur) ?
                    ((row22_value_right >> 29) & 1 ? v_high : v_low) : v_low, 0, trise);
	V(in1[30]) <+ transition(($abstime >= 22n + T_dur && $abstime < 22n + Twrite_dur) ?
                    ((row22_value_left >> 30) & 1 ? v_high : v_low) : v_low, 0, trise);
	V(in2[30]) <+ transition(($abstime >= 22n + T_dur && $abstime < 22n + Twrite_dur) ?
                    ((row22_value_right >> 30) & 1 ? v_high : v_low) : v_low, 0, trise);
	V(in1[31]) <+ transition(($abstime >= 22n + T_dur && $abstime < 22n + Twrite_dur) ?
                    ((row22_value_left >> 31) & 1 ? v_high : v_low) : v_low, 0, trise);
	V(in2[31]) <+ transition(($abstime >= 22n + T_dur && $abstime < 22n + Twrite_dur) ?
                    ((row22_value_right >> 31) & 1 ? v_high : v_low) : v_low, 0, trise);

    V(write) <+ transition(($abstime >= 23n + T_dur && $abstime < 23n + Twrite_dur) ? v_high : v_low, 0, trise);
    V(WL[23]) <+ transition(($abstime >= 23n + T_dur && $abstime < 23n + TWL_dur) ? v_high : v_low, 0, trise);
	V(in1[0]) <+ transition(($abstime >= 23n + T_dur && $abstime < 23n + Twrite_dur) ?
                    ((row23_value_left >> 0) & 1 ? v_high : v_low) : v_low, 0, trise);
	V(in2[0]) <+ transition(($abstime >= 23n + T_dur && $abstime < 23n + Twrite_dur) ?
                    ((row23_value_right >> 0) & 1 ? v_high : v_low) : v_low, 0, trise);
	V(in1[1]) <+ transition(($abstime >= 23n + T_dur && $abstime < 23n + Twrite_dur) ?
                    ((row23_value_left >> 1) & 1 ? v_high : v_low) : v_low, 0, trise);
	V(in2[1]) <+ transition(($abstime >= 23n + T_dur && $abstime < 23n + Twrite_dur) ?
                    ((row23_value_right >> 1) & 1 ? v_high : v_low) : v_low, 0, trise);
	V(in1[2]) <+ transition(($abstime >= 23n + T_dur && $abstime < 23n + Twrite_dur) ?
                    ((row23_value_left >> 2) & 1 ? v_high : v_low) : v_low, 0, trise);
	V(in2[2]) <+ transition(($abstime >= 23n + T_dur && $abstime < 23n + Twrite_dur) ?
                    ((row23_value_right >> 2) & 1 ? v_high : v_low) : v_low, 0, trise);
	V(in1[3]) <+ transition(($abstime >= 23n + T_dur && $abstime < 23n + Twrite_dur) ?
                    ((row23_value_left >> 3) & 1 ? v_high : v_low) : v_low, 0, trise);
	V(in2[3]) <+ transition(($abstime >= 23n + T_dur && $abstime < 23n + Twrite_dur) ?
                    ((row23_value_right >> 3) & 1 ? v_high : v_low) : v_low, 0, trise);
	V(in1[4]) <+ transition(($abstime >= 23n + T_dur && $abstime < 23n + Twrite_dur) ?
                    ((row23_value_left >> 4) & 1 ? v_high : v_low) : v_low, 0, trise);
	V(in2[4]) <+ transition(($abstime >= 23n + T_dur && $abstime < 23n + Twrite_dur) ?
                    ((row23_value_right >> 4) & 1 ? v_high : v_low) : v_low, 0, trise);
	V(in1[5]) <+ transition(($abstime >= 23n + T_dur && $abstime < 23n + Twrite_dur) ?
                    ((row23_value_left >> 5) & 1 ? v_high : v_low) : v_low, 0, trise);
	V(in2[5]) <+ transition(($abstime >= 23n + T_dur && $abstime < 23n + Twrite_dur) ?
                    ((row23_value_right >> 5) & 1 ? v_high : v_low) : v_low, 0, trise);
	V(in1[6]) <+ transition(($abstime >= 23n + T_dur && $abstime < 23n + Twrite_dur) ?
                    ((row23_value_left >> 6) & 1 ? v_high : v_low) : v_low, 0, trise);
	V(in2[6]) <+ transition(($abstime >= 23n + T_dur && $abstime < 23n + Twrite_dur) ?
                    ((row23_value_right >> 6) & 1 ? v_high : v_low) : v_low, 0, trise);
	V(in1[7]) <+ transition(($abstime >= 23n + T_dur && $abstime < 23n + Twrite_dur) ?
                    ((row23_value_left >> 7) & 1 ? v_high : v_low) : v_low, 0, trise);
	V(in2[7]) <+ transition(($abstime >= 23n + T_dur && $abstime < 23n + Twrite_dur) ?
                    ((row23_value_right >> 7) & 1 ? v_high : v_low) : v_low, 0, trise);
	V(in1[8]) <+ transition(($abstime >= 23n + T_dur && $abstime < 23n + Twrite_dur) ?
                    ((row23_value_left >> 8) & 1 ? v_high : v_low) : v_low, 0, trise);
	V(in2[8]) <+ transition(($abstime >= 23n + T_dur && $abstime < 23n + Twrite_dur) ?
                    ((row23_value_right >> 8) & 1 ? v_high : v_low) : v_low, 0, trise);
	V(in1[9]) <+ transition(($abstime >= 23n + T_dur && $abstime < 23n + Twrite_dur) ?
                    ((row23_value_left >> 9) & 1 ? v_high : v_low) : v_low, 0, trise);
	V(in2[9]) <+ transition(($abstime >= 23n + T_dur && $abstime < 23n + Twrite_dur) ?
                    ((row23_value_right >> 9) & 1 ? v_high : v_low) : v_low, 0, trise);
	V(in1[10]) <+ transition(($abstime >= 23n + T_dur && $abstime < 23n + Twrite_dur) ?
                    ((row23_value_left >> 10) & 1 ? v_high : v_low) : v_low, 0, trise);
	V(in2[10]) <+ transition(($abstime >= 23n + T_dur && $abstime < 23n + Twrite_dur) ?
                    ((row23_value_right >> 10) & 1 ? v_high : v_low) : v_low, 0, trise);
	V(in1[11]) <+ transition(($abstime >= 23n + T_dur && $abstime < 23n + Twrite_dur) ?
                    ((row23_value_left >> 11) & 1 ? v_high : v_low) : v_low, 0, trise);
	V(in2[11]) <+ transition(($abstime >= 23n + T_dur && $abstime < 23n + Twrite_dur) ?
                    ((row23_value_right >> 11) & 1 ? v_high : v_low) : v_low, 0, trise);
	V(in1[12]) <+ transition(($abstime >= 23n + T_dur && $abstime < 23n + Twrite_dur) ?
                    ((row23_value_left >> 12) & 1 ? v_high : v_low) : v_low, 0, trise);
	V(in2[12]) <+ transition(($abstime >= 23n + T_dur && $abstime < 23n + Twrite_dur) ?
                    ((row23_value_right >> 12) & 1 ? v_high : v_low) : v_low, 0, trise);
	V(in1[13]) <+ transition(($abstime >= 23n + T_dur && $abstime < 23n + Twrite_dur) ?
                    ((row23_value_left >> 13) & 1 ? v_high : v_low) : v_low, 0, trise);
	V(in2[13]) <+ transition(($abstime >= 23n + T_dur && $abstime < 23n + Twrite_dur) ?
                    ((row23_value_right >> 13) & 1 ? v_high : v_low) : v_low, 0, trise);
	V(in1[14]) <+ transition(($abstime >= 23n + T_dur && $abstime < 23n + Twrite_dur) ?
                    ((row23_value_left >> 14) & 1 ? v_high : v_low) : v_low, 0, trise);
	V(in2[14]) <+ transition(($abstime >= 23n + T_dur && $abstime < 23n + Twrite_dur) ?
                    ((row23_value_right >> 14) & 1 ? v_high : v_low) : v_low, 0, trise);
	V(in1[15]) <+ transition(($abstime >= 23n + T_dur && $abstime < 23n + Twrite_dur) ?
                    ((row23_value_left >> 15) & 1 ? v_high : v_low) : v_low, 0, trise);
	V(in2[15]) <+ transition(($abstime >= 23n + T_dur && $abstime < 23n + Twrite_dur) ?
                    ((row23_value_right >> 15) & 1 ? v_high : v_low) : v_low, 0, trise);
	V(in1[16]) <+ transition(($abstime >= 23n + T_dur && $abstime < 23n + Twrite_dur) ?
                    ((row23_value_left >> 16) & 1 ? v_high : v_low) : v_low, 0, trise);
	V(in2[16]) <+ transition(($abstime >= 23n + T_dur && $abstime < 23n + Twrite_dur) ?
                    ((row23_value_right >> 16) & 1 ? v_high : v_low) : v_low, 0, trise);
	V(in1[17]) <+ transition(($abstime >= 23n + T_dur && $abstime < 23n + Twrite_dur) ?
                    ((row23_value_left >> 17) & 1 ? v_high : v_low) : v_low, 0, trise);
	V(in2[17]) <+ transition(($abstime >= 23n + T_dur && $abstime < 23n + Twrite_dur) ?
                    ((row23_value_right >> 17) & 1 ? v_high : v_low) : v_low, 0, trise);
	V(in1[18]) <+ transition(($abstime >= 23n + T_dur && $abstime < 23n + Twrite_dur) ?
                    ((row23_value_left >> 18) & 1 ? v_high : v_low) : v_low, 0, trise);
	V(in2[18]) <+ transition(($abstime >= 23n + T_dur && $abstime < 23n + Twrite_dur) ?
                    ((row23_value_right >> 18) & 1 ? v_high : v_low) : v_low, 0, trise);
	V(in1[19]) <+ transition(($abstime >= 23n + T_dur && $abstime < 23n + Twrite_dur) ?
                    ((row23_value_left >> 19) & 1 ? v_high : v_low) : v_low, 0, trise);
	V(in2[19]) <+ transition(($abstime >= 23n + T_dur && $abstime < 23n + Twrite_dur) ?
                    ((row23_value_right >> 19) & 1 ? v_high : v_low) : v_low, 0, trise);
	V(in1[20]) <+ transition(($abstime >= 23n + T_dur && $abstime < 23n + Twrite_dur) ?
                    ((row23_value_left >> 20) & 1 ? v_high : v_low) : v_low, 0, trise);
	V(in2[20]) <+ transition(($abstime >= 23n + T_dur && $abstime < 23n + Twrite_dur) ?
                    ((row23_value_right >> 20) & 1 ? v_high : v_low) : v_low, 0, trise);
	V(in1[21]) <+ transition(($abstime >= 23n + T_dur && $abstime < 23n + Twrite_dur) ?
                    ((row23_value_left >> 21) & 1 ? v_high : v_low) : v_low, 0, trise);
	V(in2[21]) <+ transition(($abstime >= 23n + T_dur && $abstime < 23n + Twrite_dur) ?
                    ((row23_value_right >> 21) & 1 ? v_high : v_low) : v_low, 0, trise);
	V(in1[22]) <+ transition(($abstime >= 23n + T_dur && $abstime < 23n + Twrite_dur) ?
                    ((row23_value_left >> 22) & 1 ? v_high : v_low) : v_low, 0, trise);
	V(in2[22]) <+ transition(($abstime >= 23n + T_dur && $abstime < 23n + Twrite_dur) ?
                    ((row23_value_right >> 22) & 1 ? v_high : v_low) : v_low, 0, trise);
	V(in1[23]) <+ transition(($abstime >= 23n + T_dur && $abstime < 23n + Twrite_dur) ?
                    ((row23_value_left >> 23) & 1 ? v_high : v_low) : v_low, 0, trise);
	V(in2[23]) <+ transition(($abstime >= 23n + T_dur && $abstime < 23n + Twrite_dur) ?
                    ((row23_value_right >> 23) & 1 ? v_high : v_low) : v_low, 0, trise);
	V(in1[24]) <+ transition(($abstime >= 23n + T_dur && $abstime < 23n + Twrite_dur) ?
                    ((row23_value_left >> 24) & 1 ? v_high : v_low) : v_low, 0, trise);
	V(in2[24]) <+ transition(($abstime >= 23n + T_dur && $abstime < 23n + Twrite_dur) ?
                    ((row23_value_right >> 24) & 1 ? v_high : v_low) : v_low, 0, trise);
	V(in1[25]) <+ transition(($abstime >= 23n + T_dur && $abstime < 23n + Twrite_dur) ?
                    ((row23_value_left >> 25) & 1 ? v_high : v_low) : v_low, 0, trise);
	V(in2[25]) <+ transition(($abstime >= 23n + T_dur && $abstime < 23n + Twrite_dur) ?
                    ((row23_value_right >> 25) & 1 ? v_high : v_low) : v_low, 0, trise);
	V(in1[26]) <+ transition(($abstime >= 23n + T_dur && $abstime < 23n + Twrite_dur) ?
                    ((row23_value_left >> 26) & 1 ? v_high : v_low) : v_low, 0, trise);
	V(in2[26]) <+ transition(($abstime >= 23n + T_dur && $abstime < 23n + Twrite_dur) ?
                    ((row23_value_right >> 26) & 1 ? v_high : v_low) : v_low, 0, trise);
	V(in1[27]) <+ transition(($abstime >= 23n + T_dur && $abstime < 23n + Twrite_dur) ?
                    ((row23_value_left >> 27) & 1 ? v_high : v_low) : v_low, 0, trise);
	V(in2[27]) <+ transition(($abstime >= 23n + T_dur && $abstime < 23n + Twrite_dur) ?
                    ((row23_value_right >> 27) & 1 ? v_high : v_low) : v_low, 0, trise);
	V(in1[28]) <+ transition(($abstime >= 23n + T_dur && $abstime < 23n + Twrite_dur) ?
                    ((row23_value_left >> 28) & 1 ? v_high : v_low) : v_low, 0, trise);
	V(in2[28]) <+ transition(($abstime >= 23n + T_dur && $abstime < 23n + Twrite_dur) ?
                    ((row23_value_right >> 28) & 1 ? v_high : v_low) : v_low, 0, trise);
	V(in1[29]) <+ transition(($abstime >= 23n + T_dur && $abstime < 23n + Twrite_dur) ?
                    ((row23_value_left >> 29) & 1 ? v_high : v_low) : v_low, 0, trise);
	V(in2[29]) <+ transition(($abstime >= 23n + T_dur && $abstime < 23n + Twrite_dur) ?
                    ((row23_value_right >> 29) & 1 ? v_high : v_low) : v_low, 0, trise);
	V(in1[30]) <+ transition(($abstime >= 23n + T_dur && $abstime < 23n + Twrite_dur) ?
                    ((row23_value_left >> 30) & 1 ? v_high : v_low) : v_low, 0, trise);
	V(in2[30]) <+ transition(($abstime >= 23n + T_dur && $abstime < 23n + Twrite_dur) ?
                    ((row23_value_right >> 30) & 1 ? v_high : v_low) : v_low, 0, trise);
	V(in1[31]) <+ transition(($abstime >= 23n + T_dur && $abstime < 23n + Twrite_dur) ?
                    ((row23_value_left >> 31) & 1 ? v_high : v_low) : v_low, 0, trise);
	V(in2[31]) <+ transition(($abstime >= 23n + T_dur && $abstime < 23n + Twrite_dur) ?
                    ((row23_value_right >> 31) & 1 ? v_high : v_low) : v_low, 0, trise);

    V(write) <+ transition(($abstime >= 24n + T_dur && $abstime < 24n + Twrite_dur) ? v_high : v_low, 0, trise);
    V(WL[24]) <+ transition(($abstime >= 24n + T_dur && $abstime < 24n + TWL_dur) ? v_high : v_low, 0, trise);
	V(in1[0]) <+ transition(($abstime >= 24n + T_dur && $abstime < 24n + Twrite_dur) ?
                    ((row24_value_left >> 0) & 1 ? v_high : v_low) : v_low, 0, trise);
	V(in2[0]) <+ transition(($abstime >= 24n + T_dur && $abstime < 24n + Twrite_dur) ?
                    ((row24_value_right >> 0) & 1 ? v_high : v_low) : v_low, 0, trise);
	V(in1[1]) <+ transition(($abstime >= 24n + T_dur && $abstime < 24n + Twrite_dur) ?
                    ((row24_value_left >> 1) & 1 ? v_high : v_low) : v_low, 0, trise);
	V(in2[1]) <+ transition(($abstime >= 24n + T_dur && $abstime < 24n + Twrite_dur) ?
                    ((row24_value_right >> 1) & 1 ? v_high : v_low) : v_low, 0, trise);
	V(in1[2]) <+ transition(($abstime >= 24n + T_dur && $abstime < 24n + Twrite_dur) ?
                    ((row24_value_left >> 2) & 1 ? v_high : v_low) : v_low, 0, trise);
	V(in2[2]) <+ transition(($abstime >= 24n + T_dur && $abstime < 24n + Twrite_dur) ?
                    ((row24_value_right >> 2) & 1 ? v_high : v_low) : v_low, 0, trise);
	V(in1[3]) <+ transition(($abstime >= 24n + T_dur && $abstime < 24n + Twrite_dur) ?
                    ((row24_value_left >> 3) & 1 ? v_high : v_low) : v_low, 0, trise);
	V(in2[3]) <+ transition(($abstime >= 24n + T_dur && $abstime < 24n + Twrite_dur) ?
                    ((row24_value_right >> 3) & 1 ? v_high : v_low) : v_low, 0, trise);
	V(in1[4]) <+ transition(($abstime >= 24n + T_dur && $abstime < 24n + Twrite_dur) ?
                    ((row24_value_left >> 4) & 1 ? v_high : v_low) : v_low, 0, trise);
	V(in2[4]) <+ transition(($abstime >= 24n + T_dur && $abstime < 24n + Twrite_dur) ?
                    ((row24_value_right >> 4) & 1 ? v_high : v_low) : v_low, 0, trise);
	V(in1[5]) <+ transition(($abstime >= 24n + T_dur && $abstime < 24n + Twrite_dur) ?
                    ((row24_value_left >> 5) & 1 ? v_high : v_low) : v_low, 0, trise);
	V(in2[5]) <+ transition(($abstime >= 24n + T_dur && $abstime < 24n + Twrite_dur) ?
                    ((row24_value_right >> 5) & 1 ? v_high : v_low) : v_low, 0, trise);
	V(in1[6]) <+ transition(($abstime >= 24n + T_dur && $abstime < 24n + Twrite_dur) ?
                    ((row24_value_left >> 6) & 1 ? v_high : v_low) : v_low, 0, trise);
	V(in2[6]) <+ transition(($abstime >= 24n + T_dur && $abstime < 24n + Twrite_dur) ?
                    ((row24_value_right >> 6) & 1 ? v_high : v_low) : v_low, 0, trise);
	V(in1[7]) <+ transition(($abstime >= 24n + T_dur && $abstime < 24n + Twrite_dur) ?
                    ((row24_value_left >> 7) & 1 ? v_high : v_low) : v_low, 0, trise);
	V(in2[7]) <+ transition(($abstime >= 24n + T_dur && $abstime < 24n + Twrite_dur) ?
                    ((row24_value_right >> 7) & 1 ? v_high : v_low) : v_low, 0, trise);
	V(in1[8]) <+ transition(($abstime >= 24n + T_dur && $abstime < 24n + Twrite_dur) ?
                    ((row24_value_left >> 8) & 1 ? v_high : v_low) : v_low, 0, trise);
	V(in2[8]) <+ transition(($abstime >= 24n + T_dur && $abstime < 24n + Twrite_dur) ?
                    ((row24_value_right >> 8) & 1 ? v_high : v_low) : v_low, 0, trise);
	V(in1[9]) <+ transition(($abstime >= 24n + T_dur && $abstime < 24n + Twrite_dur) ?
                    ((row24_value_left >> 9) & 1 ? v_high : v_low) : v_low, 0, trise);
	V(in2[9]) <+ transition(($abstime >= 24n + T_dur && $abstime < 24n + Twrite_dur) ?
                    ((row24_value_right >> 9) & 1 ? v_high : v_low) : v_low, 0, trise);
	V(in1[10]) <+ transition(($abstime >= 24n + T_dur && $abstime < 24n + Twrite_dur) ?
                    ((row24_value_left >> 10) & 1 ? v_high : v_low) : v_low, 0, trise);
	V(in2[10]) <+ transition(($abstime >= 24n + T_dur && $abstime < 24n + Twrite_dur) ?
                    ((row24_value_right >> 10) & 1 ? v_high : v_low) : v_low, 0, trise);
	V(in1[11]) <+ transition(($abstime >= 24n + T_dur && $abstime < 24n + Twrite_dur) ?
                    ((row24_value_left >> 11) & 1 ? v_high : v_low) : v_low, 0, trise);
	V(in2[11]) <+ transition(($abstime >= 24n + T_dur && $abstime < 24n + Twrite_dur) ?
                    ((row24_value_right >> 11) & 1 ? v_high : v_low) : v_low, 0, trise);
	V(in1[12]) <+ transition(($abstime >= 24n + T_dur && $abstime < 24n + Twrite_dur) ?
                    ((row24_value_left >> 12) & 1 ? v_high : v_low) : v_low, 0, trise);
	V(in2[12]) <+ transition(($abstime >= 24n + T_dur && $abstime < 24n + Twrite_dur) ?
                    ((row24_value_right >> 12) & 1 ? v_high : v_low) : v_low, 0, trise);
	V(in1[13]) <+ transition(($abstime >= 24n + T_dur && $abstime < 24n + Twrite_dur) ?
                    ((row24_value_left >> 13) & 1 ? v_high : v_low) : v_low, 0, trise);
	V(in2[13]) <+ transition(($abstime >= 24n + T_dur && $abstime < 24n + Twrite_dur) ?
                    ((row24_value_right >> 13) & 1 ? v_high : v_low) : v_low, 0, trise);
	V(in1[14]) <+ transition(($abstime >= 24n + T_dur && $abstime < 24n + Twrite_dur) ?
                    ((row24_value_left >> 14) & 1 ? v_high : v_low) : v_low, 0, trise);
	V(in2[14]) <+ transition(($abstime >= 24n + T_dur && $abstime < 24n + Twrite_dur) ?
                    ((row24_value_right >> 14) & 1 ? v_high : v_low) : v_low, 0, trise);
	V(in1[15]) <+ transition(($abstime >= 24n + T_dur && $abstime < 24n + Twrite_dur) ?
                    ((row24_value_left >> 15) & 1 ? v_high : v_low) : v_low, 0, trise);
	V(in2[15]) <+ transition(($abstime >= 24n + T_dur && $abstime < 24n + Twrite_dur) ?
                    ((row24_value_right >> 15) & 1 ? v_high : v_low) : v_low, 0, trise);
	V(in1[16]) <+ transition(($abstime >= 24n + T_dur && $abstime < 24n + Twrite_dur) ?
                    ((row24_value_left >> 16) & 1 ? v_high : v_low) : v_low, 0, trise);
	V(in2[16]) <+ transition(($abstime >= 24n + T_dur && $abstime < 24n + Twrite_dur) ?
                    ((row24_value_right >> 16) & 1 ? v_high : v_low) : v_low, 0, trise);
	V(in1[17]) <+ transition(($abstime >= 24n + T_dur && $abstime < 24n + Twrite_dur) ?
                    ((row24_value_left >> 17) & 1 ? v_high : v_low) : v_low, 0, trise);
	V(in2[17]) <+ transition(($abstime >= 24n + T_dur && $abstime < 24n + Twrite_dur) ?
                    ((row24_value_right >> 17) & 1 ? v_high : v_low) : v_low, 0, trise);
	V(in1[18]) <+ transition(($abstime >= 24n + T_dur && $abstime < 24n + Twrite_dur) ?
                    ((row24_value_left >> 18) & 1 ? v_high : v_low) : v_low, 0, trise);
	V(in2[18]) <+ transition(($abstime >= 24n + T_dur && $abstime < 24n + Twrite_dur) ?
                    ((row24_value_right >> 18) & 1 ? v_high : v_low) : v_low, 0, trise);
	V(in1[19]) <+ transition(($abstime >= 24n + T_dur && $abstime < 24n + Twrite_dur) ?
                    ((row24_value_left >> 19) & 1 ? v_high : v_low) : v_low, 0, trise);
	V(in2[19]) <+ transition(($abstime >= 24n + T_dur && $abstime < 24n + Twrite_dur) ?
                    ((row24_value_right >> 19) & 1 ? v_high : v_low) : v_low, 0, trise);
	V(in1[20]) <+ transition(($abstime >= 24n + T_dur && $abstime < 24n + Twrite_dur) ?
                    ((row24_value_left >> 20) & 1 ? v_high : v_low) : v_low, 0, trise);
	V(in2[20]) <+ transition(($abstime >= 24n + T_dur && $abstime < 24n + Twrite_dur) ?
                    ((row24_value_right >> 20) & 1 ? v_high : v_low) : v_low, 0, trise);
	V(in1[21]) <+ transition(($abstime >= 24n + T_dur && $abstime < 24n + Twrite_dur) ?
                    ((row24_value_left >> 21) & 1 ? v_high : v_low) : v_low, 0, trise);
	V(in2[21]) <+ transition(($abstime >= 24n + T_dur && $abstime < 24n + Twrite_dur) ?
                    ((row24_value_right >> 21) & 1 ? v_high : v_low) : v_low, 0, trise);
	V(in1[22]) <+ transition(($abstime >= 24n + T_dur && $abstime < 24n + Twrite_dur) ?
                    ((row24_value_left >> 22) & 1 ? v_high : v_low) : v_low, 0, trise);
	V(in2[22]) <+ transition(($abstime >= 24n + T_dur && $abstime < 24n + Twrite_dur) ?
                    ((row24_value_right >> 22) & 1 ? v_high : v_low) : v_low, 0, trise);
	V(in1[23]) <+ transition(($abstime >= 24n + T_dur && $abstime < 24n + Twrite_dur) ?
                    ((row24_value_left >> 23) & 1 ? v_high : v_low) : v_low, 0, trise);
	V(in2[23]) <+ transition(($abstime >= 24n + T_dur && $abstime < 24n + Twrite_dur) ?
                    ((row24_value_right >> 23) & 1 ? v_high : v_low) : v_low, 0, trise);
	V(in1[24]) <+ transition(($abstime >= 24n + T_dur && $abstime < 24n + Twrite_dur) ?
                    ((row24_value_left >> 24) & 1 ? v_high : v_low) : v_low, 0, trise);
	V(in2[24]) <+ transition(($abstime >= 24n + T_dur && $abstime < 24n + Twrite_dur) ?
                    ((row24_value_right >> 24) & 1 ? v_high : v_low) : v_low, 0, trise);
	V(in1[25]) <+ transition(($abstime >= 24n + T_dur && $abstime < 24n + Twrite_dur) ?
                    ((row24_value_left >> 25) & 1 ? v_high : v_low) : v_low, 0, trise);
	V(in2[25]) <+ transition(($abstime >= 24n + T_dur && $abstime < 24n + Twrite_dur) ?
                    ((row24_value_right >> 25) & 1 ? v_high : v_low) : v_low, 0, trise);
	V(in1[26]) <+ transition(($abstime >= 24n + T_dur && $abstime < 24n + Twrite_dur) ?
                    ((row24_value_left >> 26) & 1 ? v_high : v_low) : v_low, 0, trise);
	V(in2[26]) <+ transition(($abstime >= 24n + T_dur && $abstime < 24n + Twrite_dur) ?
                    ((row24_value_right >> 26) & 1 ? v_high : v_low) : v_low, 0, trise);
	V(in1[27]) <+ transition(($abstime >= 24n + T_dur && $abstime < 24n + Twrite_dur) ?
                    ((row24_value_left >> 27) & 1 ? v_high : v_low) : v_low, 0, trise);
	V(in2[27]) <+ transition(($abstime >= 24n + T_dur && $abstime < 24n + Twrite_dur) ?
                    ((row24_value_right >> 27) & 1 ? v_high : v_low) : v_low, 0, trise);
	V(in1[28]) <+ transition(($abstime >= 24n + T_dur && $abstime < 24n + Twrite_dur) ?
                    ((row24_value_left >> 28) & 1 ? v_high : v_low) : v_low, 0, trise);
	V(in2[28]) <+ transition(($abstime >= 24n + T_dur && $abstime < 24n + Twrite_dur) ?
                    ((row24_value_right >> 28) & 1 ? v_high : v_low) : v_low, 0, trise);
	V(in1[29]) <+ transition(($abstime >= 24n + T_dur && $abstime < 24n + Twrite_dur) ?
                    ((row24_value_left >> 29) & 1 ? v_high : v_low) : v_low, 0, trise);
	V(in2[29]) <+ transition(($abstime >= 24n + T_dur && $abstime < 24n + Twrite_dur) ?
                    ((row24_value_right >> 29) & 1 ? v_high : v_low) : v_low, 0, trise);
	V(in1[30]) <+ transition(($abstime >= 24n + T_dur && $abstime < 24n + Twrite_dur) ?
                    ((row24_value_left >> 30) & 1 ? v_high : v_low) : v_low, 0, trise);
	V(in2[30]) <+ transition(($abstime >= 24n + T_dur && $abstime < 24n + Twrite_dur) ?
                    ((row24_value_right >> 30) & 1 ? v_high : v_low) : v_low, 0, trise);
	V(in1[31]) <+ transition(($abstime >= 24n + T_dur && $abstime < 24n + Twrite_dur) ?
                    ((row24_value_left >> 31) & 1 ? v_high : v_low) : v_low, 0, trise);
	V(in2[31]) <+ transition(($abstime >= 24n + T_dur && $abstime < 24n + Twrite_dur) ?
                    ((row24_value_right >> 31) & 1 ? v_high : v_low) : v_low, 0, trise);

    V(write) <+ transition(($abstime >= 25n + T_dur && $abstime < 25n + Twrite_dur) ? v_high : v_low, 0, trise);
    V(WL[25]) <+ transition(($abstime >= 25n + T_dur && $abstime < 25n + TWL_dur) ? v_high : v_low, 0, trise);
	V(in1[0]) <+ transition(($abstime >= 25n + T_dur && $abstime < 25n + Twrite_dur) ?
                    ((row25_value_left >> 0) & 1 ? v_high : v_low) : v_low, 0, trise);
	V(in2[0]) <+ transition(($abstime >= 25n + T_dur && $abstime < 25n + Twrite_dur) ?
                    ((row25_value_right >> 0) & 1 ? v_high : v_low) : v_low, 0, trise);
	V(in1[1]) <+ transition(($abstime >= 25n + T_dur && $abstime < 25n + Twrite_dur) ?
                    ((row25_value_left >> 1) & 1 ? v_high : v_low) : v_low, 0, trise);
	V(in2[1]) <+ transition(($abstime >= 25n + T_dur && $abstime < 25n + Twrite_dur) ?
                    ((row25_value_right >> 1) & 1 ? v_high : v_low) : v_low, 0, trise);
	V(in1[2]) <+ transition(($abstime >= 25n + T_dur && $abstime < 25n + Twrite_dur) ?
                    ((row25_value_left >> 2) & 1 ? v_high : v_low) : v_low, 0, trise);
	V(in2[2]) <+ transition(($abstime >= 25n + T_dur && $abstime < 25n + Twrite_dur) ?
                    ((row25_value_right >> 2) & 1 ? v_high : v_low) : v_low, 0, trise);
	V(in1[3]) <+ transition(($abstime >= 25n + T_dur && $abstime < 25n + Twrite_dur) ?
                    ((row25_value_left >> 3) & 1 ? v_high : v_low) : v_low, 0, trise);
	V(in2[3]) <+ transition(($abstime >= 25n + T_dur && $abstime < 25n + Twrite_dur) ?
                    ((row25_value_right >> 3) & 1 ? v_high : v_low) : v_low, 0, trise);
	V(in1[4]) <+ transition(($abstime >= 25n + T_dur && $abstime < 25n + Twrite_dur) ?
                    ((row25_value_left >> 4) & 1 ? v_high : v_low) : v_low, 0, trise);
	V(in2[4]) <+ transition(($abstime >= 25n + T_dur && $abstime < 25n + Twrite_dur) ?
                    ((row25_value_right >> 4) & 1 ? v_high : v_low) : v_low, 0, trise);
	V(in1[5]) <+ transition(($abstime >= 25n + T_dur && $abstime < 25n + Twrite_dur) ?
                    ((row25_value_left >> 5) & 1 ? v_high : v_low) : v_low, 0, trise);
	V(in2[5]) <+ transition(($abstime >= 25n + T_dur && $abstime < 25n + Twrite_dur) ?
                    ((row25_value_right >> 5) & 1 ? v_high : v_low) : v_low, 0, trise);
	V(in1[6]) <+ transition(($abstime >= 25n + T_dur && $abstime < 25n + Twrite_dur) ?
                    ((row25_value_left >> 6) & 1 ? v_high : v_low) : v_low, 0, trise);
	V(in2[6]) <+ transition(($abstime >= 25n + T_dur && $abstime < 25n + Twrite_dur) ?
                    ((row25_value_right >> 6) & 1 ? v_high : v_low) : v_low, 0, trise);
	V(in1[7]) <+ transition(($abstime >= 25n + T_dur && $abstime < 25n + Twrite_dur) ?
                    ((row25_value_left >> 7) & 1 ? v_high : v_low) : v_low, 0, trise);
	V(in2[7]) <+ transition(($abstime >= 25n + T_dur && $abstime < 25n + Twrite_dur) ?
                    ((row25_value_right >> 7) & 1 ? v_high : v_low) : v_low, 0, trise);
	V(in1[8]) <+ transition(($abstime >= 25n + T_dur && $abstime < 25n + Twrite_dur) ?
                    ((row25_value_left >> 8) & 1 ? v_high : v_low) : v_low, 0, trise);
	V(in2[8]) <+ transition(($abstime >= 25n + T_dur && $abstime < 25n + Twrite_dur) ?
                    ((row25_value_right >> 8) & 1 ? v_high : v_low) : v_low, 0, trise);
	V(in1[9]) <+ transition(($abstime >= 25n + T_dur && $abstime < 25n + Twrite_dur) ?
                    ((row25_value_left >> 9) & 1 ? v_high : v_low) : v_low, 0, trise);
	V(in2[9]) <+ transition(($abstime >= 25n + T_dur && $abstime < 25n + Twrite_dur) ?
                    ((row25_value_right >> 9) & 1 ? v_high : v_low) : v_low, 0, trise);
	V(in1[10]) <+ transition(($abstime >= 25n + T_dur && $abstime < 25n + Twrite_dur) ?
                    ((row25_value_left >> 10) & 1 ? v_high : v_low) : v_low, 0, trise);
	V(in2[10]) <+ transition(($abstime >= 25n + T_dur && $abstime < 25n + Twrite_dur) ?
                    ((row25_value_right >> 10) & 1 ? v_high : v_low) : v_low, 0, trise);
	V(in1[11]) <+ transition(($abstime >= 25n + T_dur && $abstime < 25n + Twrite_dur) ?
                    ((row25_value_left >> 11) & 1 ? v_high : v_low) : v_low, 0, trise);
	V(in2[11]) <+ transition(($abstime >= 25n + T_dur && $abstime < 25n + Twrite_dur) ?
                    ((row25_value_right >> 11) & 1 ? v_high : v_low) : v_low, 0, trise);
	V(in1[12]) <+ transition(($abstime >= 25n + T_dur && $abstime < 25n + Twrite_dur) ?
                    ((row25_value_left >> 12) & 1 ? v_high : v_low) : v_low, 0, trise);
	V(in2[12]) <+ transition(($abstime >= 25n + T_dur && $abstime < 25n + Twrite_dur) ?
                    ((row25_value_right >> 12) & 1 ? v_high : v_low) : v_low, 0, trise);
	V(in1[13]) <+ transition(($abstime >= 25n + T_dur && $abstime < 25n + Twrite_dur) ?
                    ((row25_value_left >> 13) & 1 ? v_high : v_low) : v_low, 0, trise);
	V(in2[13]) <+ transition(($abstime >= 25n + T_dur && $abstime < 25n + Twrite_dur) ?
                    ((row25_value_right >> 13) & 1 ? v_high : v_low) : v_low, 0, trise);
	V(in1[14]) <+ transition(($abstime >= 25n + T_dur && $abstime < 25n + Twrite_dur) ?
                    ((row25_value_left >> 14) & 1 ? v_high : v_low) : v_low, 0, trise);
	V(in2[14]) <+ transition(($abstime >= 25n + T_dur && $abstime < 25n + Twrite_dur) ?
                    ((row25_value_right >> 14) & 1 ? v_high : v_low) : v_low, 0, trise);
	V(in1[15]) <+ transition(($abstime >= 25n + T_dur && $abstime < 25n + Twrite_dur) ?
                    ((row25_value_left >> 15) & 1 ? v_high : v_low) : v_low, 0, trise);
	V(in2[15]) <+ transition(($abstime >= 25n + T_dur && $abstime < 25n + Twrite_dur) ?
                    ((row25_value_right >> 15) & 1 ? v_high : v_low) : v_low, 0, trise);
	V(in1[16]) <+ transition(($abstime >= 25n + T_dur && $abstime < 25n + Twrite_dur) ?
                    ((row25_value_left >> 16) & 1 ? v_high : v_low) : v_low, 0, trise);
	V(in2[16]) <+ transition(($abstime >= 25n + T_dur && $abstime < 25n + Twrite_dur) ?
                    ((row25_value_right >> 16) & 1 ? v_high : v_low) : v_low, 0, trise);
	V(in1[17]) <+ transition(($abstime >= 25n + T_dur && $abstime < 25n + Twrite_dur) ?
                    ((row25_value_left >> 17) & 1 ? v_high : v_low) : v_low, 0, trise);
	V(in2[17]) <+ transition(($abstime >= 25n + T_dur && $abstime < 25n + Twrite_dur) ?
                    ((row25_value_right >> 17) & 1 ? v_high : v_low) : v_low, 0, trise);
	V(in1[18]) <+ transition(($abstime >= 25n + T_dur && $abstime < 25n + Twrite_dur) ?
                    ((row25_value_left >> 18) & 1 ? v_high : v_low) : v_low, 0, trise);
	V(in2[18]) <+ transition(($abstime >= 25n + T_dur && $abstime < 25n + Twrite_dur) ?
                    ((row25_value_right >> 18) & 1 ? v_high : v_low) : v_low, 0, trise);
	V(in1[19]) <+ transition(($abstime >= 25n + T_dur && $abstime < 25n + Twrite_dur) ?
                    ((row25_value_left >> 19) & 1 ? v_high : v_low) : v_low, 0, trise);
	V(in2[19]) <+ transition(($abstime >= 25n + T_dur && $abstime < 25n + Twrite_dur) ?
                    ((row25_value_right >> 19) & 1 ? v_high : v_low) : v_low, 0, trise);
	V(in1[20]) <+ transition(($abstime >= 25n + T_dur && $abstime < 25n + Twrite_dur) ?
                    ((row25_value_left >> 20) & 1 ? v_high : v_low) : v_low, 0, trise);
	V(in2[20]) <+ transition(($abstime >= 25n + T_dur && $abstime < 25n + Twrite_dur) ?
                    ((row25_value_right >> 20) & 1 ? v_high : v_low) : v_low, 0, trise);
	V(in1[21]) <+ transition(($abstime >= 25n + T_dur && $abstime < 25n + Twrite_dur) ?
                    ((row25_value_left >> 21) & 1 ? v_high : v_low) : v_low, 0, trise);
	V(in2[21]) <+ transition(($abstime >= 25n + T_dur && $abstime < 25n + Twrite_dur) ?
                    ((row25_value_right >> 21) & 1 ? v_high : v_low) : v_low, 0, trise);
	V(in1[22]) <+ transition(($abstime >= 25n + T_dur && $abstime < 25n + Twrite_dur) ?
                    ((row25_value_left >> 22) & 1 ? v_high : v_low) : v_low, 0, trise);
	V(in2[22]) <+ transition(($abstime >= 25n + T_dur && $abstime < 25n + Twrite_dur) ?
                    ((row25_value_right >> 22) & 1 ? v_high : v_low) : v_low, 0, trise);
	V(in1[23]) <+ transition(($abstime >= 25n + T_dur && $abstime < 25n + Twrite_dur) ?
                    ((row25_value_left >> 23) & 1 ? v_high : v_low) : v_low, 0, trise);
	V(in2[23]) <+ transition(($abstime >= 25n + T_dur && $abstime < 25n + Twrite_dur) ?
                    ((row25_value_right >> 23) & 1 ? v_high : v_low) : v_low, 0, trise);
	V(in1[24]) <+ transition(($abstime >= 25n + T_dur && $abstime < 25n + Twrite_dur) ?
                    ((row25_value_left >> 24) & 1 ? v_high : v_low) : v_low, 0, trise);
	V(in2[24]) <+ transition(($abstime >= 25n + T_dur && $abstime < 25n + Twrite_dur) ?
                    ((row25_value_right >> 24) & 1 ? v_high : v_low) : v_low, 0, trise);
	V(in1[25]) <+ transition(($abstime >= 25n + T_dur && $abstime < 25n + Twrite_dur) ?
                    ((row25_value_left >> 25) & 1 ? v_high : v_low) : v_low, 0, trise);
	V(in2[25]) <+ transition(($abstime >= 25n + T_dur && $abstime < 25n + Twrite_dur) ?
                    ((row25_value_right >> 25) & 1 ? v_high : v_low) : v_low, 0, trise);
	V(in1[26]) <+ transition(($abstime >= 25n + T_dur && $abstime < 25n + Twrite_dur) ?
                    ((row25_value_left >> 26) & 1 ? v_high : v_low) : v_low, 0, trise);
	V(in2[26]) <+ transition(($abstime >= 25n + T_dur && $abstime < 25n + Twrite_dur) ?
                    ((row25_value_right >> 26) & 1 ? v_high : v_low) : v_low, 0, trise);
	V(in1[27]) <+ transition(($abstime >= 25n + T_dur && $abstime < 25n + Twrite_dur) ?
                    ((row25_value_left >> 27) & 1 ? v_high : v_low) : v_low, 0, trise);
	V(in2[27]) <+ transition(($abstime >= 25n + T_dur && $abstime < 25n + Twrite_dur) ?
                    ((row25_value_right >> 27) & 1 ? v_high : v_low) : v_low, 0, trise);
	V(in1[28]) <+ transition(($abstime >= 25n + T_dur && $abstime < 25n + Twrite_dur) ?
                    ((row25_value_left >> 28) & 1 ? v_high : v_low) : v_low, 0, trise);
	V(in2[28]) <+ transition(($abstime >= 25n + T_dur && $abstime < 25n + Twrite_dur) ?
                    ((row25_value_right >> 28) & 1 ? v_high : v_low) : v_low, 0, trise);
	V(in1[29]) <+ transition(($abstime >= 25n + T_dur && $abstime < 25n + Twrite_dur) ?
                    ((row25_value_left >> 29) & 1 ? v_high : v_low) : v_low, 0, trise);
	V(in2[29]) <+ transition(($abstime >= 25n + T_dur && $abstime < 25n + Twrite_dur) ?
                    ((row25_value_right >> 29) & 1 ? v_high : v_low) : v_low, 0, trise);
	V(in1[30]) <+ transition(($abstime >= 25n + T_dur && $abstime < 25n + Twrite_dur) ?
                    ((row25_value_left >> 30) & 1 ? v_high : v_low) : v_low, 0, trise);
	V(in2[30]) <+ transition(($abstime >= 25n + T_dur && $abstime < 25n + Twrite_dur) ?
                    ((row25_value_right >> 30) & 1 ? v_high : v_low) : v_low, 0, trise);
	V(in1[31]) <+ transition(($abstime >= 25n + T_dur && $abstime < 25n + Twrite_dur) ?
                    ((row25_value_left >> 31) & 1 ? v_high : v_low) : v_low, 0, trise);
	V(in2[31]) <+ transition(($abstime >= 25n + T_dur && $abstime < 25n + Twrite_dur) ?
                    ((row25_value_right >> 31) & 1 ? v_high : v_low) : v_low, 0, trise);

    V(write) <+ transition(($abstime >= 26n + T_dur && $abstime < 26n + Twrite_dur) ? v_high : v_low, 0, trise);
    V(WL[26]) <+ transition(($abstime >= 26n + T_dur && $abstime < 26n + TWL_dur) ? v_high : v_low, 0, trise);
	V(in1[0]) <+ transition(($abstime >= 26n + T_dur && $abstime < 26n + Twrite_dur) ?
                    ((row26_value_left >> 0) & 1 ? v_high : v_low) : v_low, 0, trise);
	V(in2[0]) <+ transition(($abstime >= 26n + T_dur && $abstime < 26n + Twrite_dur) ?
                    ((row26_value_right >> 0) & 1 ? v_high : v_low) : v_low, 0, trise);
	V(in1[1]) <+ transition(($abstime >= 26n + T_dur && $abstime < 26n + Twrite_dur) ?
                    ((row26_value_left >> 1) & 1 ? v_high : v_low) : v_low, 0, trise);
	V(in2[1]) <+ transition(($abstime >= 26n + T_dur && $abstime < 26n + Twrite_dur) ?
                    ((row26_value_right >> 1) & 1 ? v_high : v_low) : v_low, 0, trise);
	V(in1[2]) <+ transition(($abstime >= 26n + T_dur && $abstime < 26n + Twrite_dur) ?
                    ((row26_value_left >> 2) & 1 ? v_high : v_low) : v_low, 0, trise);
	V(in2[2]) <+ transition(($abstime >= 26n + T_dur && $abstime < 26n + Twrite_dur) ?
                    ((row26_value_right >> 2) & 1 ? v_high : v_low) : v_low, 0, trise);
	V(in1[3]) <+ transition(($abstime >= 26n + T_dur && $abstime < 26n + Twrite_dur) ?
                    ((row26_value_left >> 3) & 1 ? v_high : v_low) : v_low, 0, trise);
	V(in2[3]) <+ transition(($abstime >= 26n + T_dur && $abstime < 26n + Twrite_dur) ?
                    ((row26_value_right >> 3) & 1 ? v_high : v_low) : v_low, 0, trise);
	V(in1[4]) <+ transition(($abstime >= 26n + T_dur && $abstime < 26n + Twrite_dur) ?
                    ((row26_value_left >> 4) & 1 ? v_high : v_low) : v_low, 0, trise);
	V(in2[4]) <+ transition(($abstime >= 26n + T_dur && $abstime < 26n + Twrite_dur) ?
                    ((row26_value_right >> 4) & 1 ? v_high : v_low) : v_low, 0, trise);
	V(in1[5]) <+ transition(($abstime >= 26n + T_dur && $abstime < 26n + Twrite_dur) ?
                    ((row26_value_left >> 5) & 1 ? v_high : v_low) : v_low, 0, trise);
	V(in2[5]) <+ transition(($abstime >= 26n + T_dur && $abstime < 26n + Twrite_dur) ?
                    ((row26_value_right >> 5) & 1 ? v_high : v_low) : v_low, 0, trise);
	V(in1[6]) <+ transition(($abstime >= 26n + T_dur && $abstime < 26n + Twrite_dur) ?
                    ((row26_value_left >> 6) & 1 ? v_high : v_low) : v_low, 0, trise);
	V(in2[6]) <+ transition(($abstime >= 26n + T_dur && $abstime < 26n + Twrite_dur) ?
                    ((row26_value_right >> 6) & 1 ? v_high : v_low) : v_low, 0, trise);
	V(in1[7]) <+ transition(($abstime >= 26n + T_dur && $abstime < 26n + Twrite_dur) ?
                    ((row26_value_left >> 7) & 1 ? v_high : v_low) : v_low, 0, trise);
	V(in2[7]) <+ transition(($abstime >= 26n + T_dur && $abstime < 26n + Twrite_dur) ?
                    ((row26_value_right >> 7) & 1 ? v_high : v_low) : v_low, 0, trise);
	V(in1[8]) <+ transition(($abstime >= 26n + T_dur && $abstime < 26n + Twrite_dur) ?
                    ((row26_value_left >> 8) & 1 ? v_high : v_low) : v_low, 0, trise);
	V(in2[8]) <+ transition(($abstime >= 26n + T_dur && $abstime < 26n + Twrite_dur) ?
                    ((row26_value_right >> 8) & 1 ? v_high : v_low) : v_low, 0, trise);
	V(in1[9]) <+ transition(($abstime >= 26n + T_dur && $abstime < 26n + Twrite_dur) ?
                    ((row26_value_left >> 9) & 1 ? v_high : v_low) : v_low, 0, trise);
	V(in2[9]) <+ transition(($abstime >= 26n + T_dur && $abstime < 26n + Twrite_dur) ?
                    ((row26_value_right >> 9) & 1 ? v_high : v_low) : v_low, 0, trise);
	V(in1[10]) <+ transition(($abstime >= 26n + T_dur && $abstime < 26n + Twrite_dur) ?
                    ((row26_value_left >> 10) & 1 ? v_high : v_low) : v_low, 0, trise);
	V(in2[10]) <+ transition(($abstime >= 26n + T_dur && $abstime < 26n + Twrite_dur) ?
                    ((row26_value_right >> 10) & 1 ? v_high : v_low) : v_low, 0, trise);
	V(in1[11]) <+ transition(($abstime >= 26n + T_dur && $abstime < 26n + Twrite_dur) ?
                    ((row26_value_left >> 11) & 1 ? v_high : v_low) : v_low, 0, trise);
	V(in2[11]) <+ transition(($abstime >= 26n + T_dur && $abstime < 26n + Twrite_dur) ?
                    ((row26_value_right >> 11) & 1 ? v_high : v_low) : v_low, 0, trise);
	V(in1[12]) <+ transition(($abstime >= 26n + T_dur && $abstime < 26n + Twrite_dur) ?
                    ((row26_value_left >> 12) & 1 ? v_high : v_low) : v_low, 0, trise);
	V(in2[12]) <+ transition(($abstime >= 26n + T_dur && $abstime < 26n + Twrite_dur) ?
                    ((row26_value_right >> 12) & 1 ? v_high : v_low) : v_low, 0, trise);
	V(in1[13]) <+ transition(($abstime >= 26n + T_dur && $abstime < 26n + Twrite_dur) ?
                    ((row26_value_left >> 13) & 1 ? v_high : v_low) : v_low, 0, trise);
	V(in2[13]) <+ transition(($abstime >= 26n + T_dur && $abstime < 26n + Twrite_dur) ?
                    ((row26_value_right >> 13) & 1 ? v_high : v_low) : v_low, 0, trise);
	V(in1[14]) <+ transition(($abstime >= 26n + T_dur && $abstime < 26n + Twrite_dur) ?
                    ((row26_value_left >> 14) & 1 ? v_high : v_low) : v_low, 0, trise);
	V(in2[14]) <+ transition(($abstime >= 26n + T_dur && $abstime < 26n + Twrite_dur) ?
                    ((row26_value_right >> 14) & 1 ? v_high : v_low) : v_low, 0, trise);
	V(in1[15]) <+ transition(($abstime >= 26n + T_dur && $abstime < 26n + Twrite_dur) ?
                    ((row26_value_left >> 15) & 1 ? v_high : v_low) : v_low, 0, trise);
	V(in2[15]) <+ transition(($abstime >= 26n + T_dur && $abstime < 26n + Twrite_dur) ?
                    ((row26_value_right >> 15) & 1 ? v_high : v_low) : v_low, 0, trise);
	V(in1[16]) <+ transition(($abstime >= 26n + T_dur && $abstime < 26n + Twrite_dur) ?
                    ((row26_value_left >> 16) & 1 ? v_high : v_low) : v_low, 0, trise);
	V(in2[16]) <+ transition(($abstime >= 26n + T_dur && $abstime < 26n + Twrite_dur) ?
                    ((row26_value_right >> 16) & 1 ? v_high : v_low) : v_low, 0, trise);
	V(in1[17]) <+ transition(($abstime >= 26n + T_dur && $abstime < 26n + Twrite_dur) ?
                    ((row26_value_left >> 17) & 1 ? v_high : v_low) : v_low, 0, trise);
	V(in2[17]) <+ transition(($abstime >= 26n + T_dur && $abstime < 26n + Twrite_dur) ?
                    ((row26_value_right >> 17) & 1 ? v_high : v_low) : v_low, 0, trise);
	V(in1[18]) <+ transition(($abstime >= 26n + T_dur && $abstime < 26n + Twrite_dur) ?
                    ((row26_value_left >> 18) & 1 ? v_high : v_low) : v_low, 0, trise);
	V(in2[18]) <+ transition(($abstime >= 26n + T_dur && $abstime < 26n + Twrite_dur) ?
                    ((row26_value_right >> 18) & 1 ? v_high : v_low) : v_low, 0, trise);
	V(in1[19]) <+ transition(($abstime >= 26n + T_dur && $abstime < 26n + Twrite_dur) ?
                    ((row26_value_left >> 19) & 1 ? v_high : v_low) : v_low, 0, trise);
	V(in2[19]) <+ transition(($abstime >= 26n + T_dur && $abstime < 26n + Twrite_dur) ?
                    ((row26_value_right >> 19) & 1 ? v_high : v_low) : v_low, 0, trise);
	V(in1[20]) <+ transition(($abstime >= 26n + T_dur && $abstime < 26n + Twrite_dur) ?
                    ((row26_value_left >> 20) & 1 ? v_high : v_low) : v_low, 0, trise);
	V(in2[20]) <+ transition(($abstime >= 26n + T_dur && $abstime < 26n + Twrite_dur) ?
                    ((row26_value_right >> 20) & 1 ? v_high : v_low) : v_low, 0, trise);
	V(in1[21]) <+ transition(($abstime >= 26n + T_dur && $abstime < 26n + Twrite_dur) ?
                    ((row26_value_left >> 21) & 1 ? v_high : v_low) : v_low, 0, trise);
	V(in2[21]) <+ transition(($abstime >= 26n + T_dur && $abstime < 26n + Twrite_dur) ?
                    ((row26_value_right >> 21) & 1 ? v_high : v_low) : v_low, 0, trise);
	V(in1[22]) <+ transition(($abstime >= 26n + T_dur && $abstime < 26n + Twrite_dur) ?
                    ((row26_value_left >> 22) & 1 ? v_high : v_low) : v_low, 0, trise);
	V(in2[22]) <+ transition(($abstime >= 26n + T_dur && $abstime < 26n + Twrite_dur) ?
                    ((row26_value_right >> 22) & 1 ? v_high : v_low) : v_low, 0, trise);
	V(in1[23]) <+ transition(($abstime >= 26n + T_dur && $abstime < 26n + Twrite_dur) ?
                    ((row26_value_left >> 23) & 1 ? v_high : v_low) : v_low, 0, trise);
	V(in2[23]) <+ transition(($abstime >= 26n + T_dur && $abstime < 26n + Twrite_dur) ?
                    ((row26_value_right >> 23) & 1 ? v_high : v_low) : v_low, 0, trise);
	V(in1[24]) <+ transition(($abstime >= 26n + T_dur && $abstime < 26n + Twrite_dur) ?
                    ((row26_value_left >> 24) & 1 ? v_high : v_low) : v_low, 0, trise);
	V(in2[24]) <+ transition(($abstime >= 26n + T_dur && $abstime < 26n + Twrite_dur) ?
                    ((row26_value_right >> 24) & 1 ? v_high : v_low) : v_low, 0, trise);
	V(in1[25]) <+ transition(($abstime >= 26n + T_dur && $abstime < 26n + Twrite_dur) ?
                    ((row26_value_left >> 25) & 1 ? v_high : v_low) : v_low, 0, trise);
	V(in2[25]) <+ transition(($abstime >= 26n + T_dur && $abstime < 26n + Twrite_dur) ?
                    ((row26_value_right >> 25) & 1 ? v_high : v_low) : v_low, 0, trise);
	V(in1[26]) <+ transition(($abstime >= 26n + T_dur && $abstime < 26n + Twrite_dur) ?
                    ((row26_value_left >> 26) & 1 ? v_high : v_low) : v_low, 0, trise);
	V(in2[26]) <+ transition(($abstime >= 26n + T_dur && $abstime < 26n + Twrite_dur) ?
                    ((row26_value_right >> 26) & 1 ? v_high : v_low) : v_low, 0, trise);
	V(in1[27]) <+ transition(($abstime >= 26n + T_dur && $abstime < 26n + Twrite_dur) ?
                    ((row26_value_left >> 27) & 1 ? v_high : v_low) : v_low, 0, trise);
	V(in2[27]) <+ transition(($abstime >= 26n + T_dur && $abstime < 26n + Twrite_dur) ?
                    ((row26_value_right >> 27) & 1 ? v_high : v_low) : v_low, 0, trise);
	V(in1[28]) <+ transition(($abstime >= 26n + T_dur && $abstime < 26n + Twrite_dur) ?
                    ((row26_value_left >> 28) & 1 ? v_high : v_low) : v_low, 0, trise);
	V(in2[28]) <+ transition(($abstime >= 26n + T_dur && $abstime < 26n + Twrite_dur) ?
                    ((row26_value_right >> 28) & 1 ? v_high : v_low) : v_low, 0, trise);
	V(in1[29]) <+ transition(($abstime >= 26n + T_dur && $abstime < 26n + Twrite_dur) ?
                    ((row26_value_left >> 29) & 1 ? v_high : v_low) : v_low, 0, trise);
	V(in2[29]) <+ transition(($abstime >= 26n + T_dur && $abstime < 26n + Twrite_dur) ?
                    ((row26_value_right >> 29) & 1 ? v_high : v_low) : v_low, 0, trise);
	V(in1[30]) <+ transition(($abstime >= 26n + T_dur && $abstime < 26n + Twrite_dur) ?
                    ((row26_value_left >> 30) & 1 ? v_high : v_low) : v_low, 0, trise);
	V(in2[30]) <+ transition(($abstime >= 26n + T_dur && $abstime < 26n + Twrite_dur) ?
                    ((row26_value_right >> 30) & 1 ? v_high : v_low) : v_low, 0, trise);
	V(in1[31]) <+ transition(($abstime >= 26n + T_dur && $abstime < 26n + Twrite_dur) ?
                    ((row26_value_left >> 31) & 1 ? v_high : v_low) : v_low, 0, trise);
	V(in2[31]) <+ transition(($abstime >= 26n + T_dur && $abstime < 26n + Twrite_dur) ?
                    ((row26_value_right >> 31) & 1 ? v_high : v_low) : v_low, 0, trise);

    V(write) <+ transition(($abstime >= 27n + T_dur && $abstime < 27n + Twrite_dur) ? v_high : v_low, 0, trise);
    V(WL[27]) <+ transition(($abstime >= 27n + T_dur && $abstime < 27n + TWL_dur) ? v_high : v_low, 0, trise);
	V(in1[0]) <+ transition(($abstime >= 27n + T_dur && $abstime < 27n + Twrite_dur) ?
                    ((row27_value_left >> 0) & 1 ? v_high : v_low) : v_low, 0, trise);
	V(in2[0]) <+ transition(($abstime >= 27n + T_dur && $abstime < 27n + Twrite_dur) ?
                    ((row27_value_right >> 0) & 1 ? v_high : v_low) : v_low, 0, trise);
	V(in1[1]) <+ transition(($abstime >= 27n + T_dur && $abstime < 27n + Twrite_dur) ?
                    ((row27_value_left >> 1) & 1 ? v_high : v_low) : v_low, 0, trise);
	V(in2[1]) <+ transition(($abstime >= 27n + T_dur && $abstime < 27n + Twrite_dur) ?
                    ((row27_value_right >> 1) & 1 ? v_high : v_low) : v_low, 0, trise);
	V(in1[2]) <+ transition(($abstime >= 27n + T_dur && $abstime < 27n + Twrite_dur) ?
                    ((row27_value_left >> 2) & 1 ? v_high : v_low) : v_low, 0, trise);
	V(in2[2]) <+ transition(($abstime >= 27n + T_dur && $abstime < 27n + Twrite_dur) ?
                    ((row27_value_right >> 2) & 1 ? v_high : v_low) : v_low, 0, trise);
	V(in1[3]) <+ transition(($abstime >= 27n + T_dur && $abstime < 27n + Twrite_dur) ?
                    ((row27_value_left >> 3) & 1 ? v_high : v_low) : v_low, 0, trise);
	V(in2[3]) <+ transition(($abstime >= 27n + T_dur && $abstime < 27n + Twrite_dur) ?
                    ((row27_value_right >> 3) & 1 ? v_high : v_low) : v_low, 0, trise);
	V(in1[4]) <+ transition(($abstime >= 27n + T_dur && $abstime < 27n + Twrite_dur) ?
                    ((row27_value_left >> 4) & 1 ? v_high : v_low) : v_low, 0, trise);
	V(in2[4]) <+ transition(($abstime >= 27n + T_dur && $abstime < 27n + Twrite_dur) ?
                    ((row27_value_right >> 4) & 1 ? v_high : v_low) : v_low, 0, trise);
	V(in1[5]) <+ transition(($abstime >= 27n + T_dur && $abstime < 27n + Twrite_dur) ?
                    ((row27_value_left >> 5) & 1 ? v_high : v_low) : v_low, 0, trise);
	V(in2[5]) <+ transition(($abstime >= 27n + T_dur && $abstime < 27n + Twrite_dur) ?
                    ((row27_value_right >> 5) & 1 ? v_high : v_low) : v_low, 0, trise);
	V(in1[6]) <+ transition(($abstime >= 27n + T_dur && $abstime < 27n + Twrite_dur) ?
                    ((row27_value_left >> 6) & 1 ? v_high : v_low) : v_low, 0, trise);
	V(in2[6]) <+ transition(($abstime >= 27n + T_dur && $abstime < 27n + Twrite_dur) ?
                    ((row27_value_right >> 6) & 1 ? v_high : v_low) : v_low, 0, trise);
	V(in1[7]) <+ transition(($abstime >= 27n + T_dur && $abstime < 27n + Twrite_dur) ?
                    ((row27_value_left >> 7) & 1 ? v_high : v_low) : v_low, 0, trise);
	V(in2[7]) <+ transition(($abstime >= 27n + T_dur && $abstime < 27n + Twrite_dur) ?
                    ((row27_value_right >> 7) & 1 ? v_high : v_low) : v_low, 0, trise);
	V(in1[8]) <+ transition(($abstime >= 27n + T_dur && $abstime < 27n + Twrite_dur) ?
                    ((row27_value_left >> 8) & 1 ? v_high : v_low) : v_low, 0, trise);
	V(in2[8]) <+ transition(($abstime >= 27n + T_dur && $abstime < 27n + Twrite_dur) ?
                    ((row27_value_right >> 8) & 1 ? v_high : v_low) : v_low, 0, trise);
	V(in1[9]) <+ transition(($abstime >= 27n + T_dur && $abstime < 27n + Twrite_dur) ?
                    ((row27_value_left >> 9) & 1 ? v_high : v_low) : v_low, 0, trise);
	V(in2[9]) <+ transition(($abstime >= 27n + T_dur && $abstime < 27n + Twrite_dur) ?
                    ((row27_value_right >> 9) & 1 ? v_high : v_low) : v_low, 0, trise);
	V(in1[10]) <+ transition(($abstime >= 27n + T_dur && $abstime < 27n + Twrite_dur) ?
                    ((row27_value_left >> 10) & 1 ? v_high : v_low) : v_low, 0, trise);
	V(in2[10]) <+ transition(($abstime >= 27n + T_dur && $abstime < 27n + Twrite_dur) ?
                    ((row27_value_right >> 10) & 1 ? v_high : v_low) : v_low, 0, trise);
	V(in1[11]) <+ transition(($abstime >= 27n + T_dur && $abstime < 27n + Twrite_dur) ?
                    ((row27_value_left >> 11) & 1 ? v_high : v_low) : v_low, 0, trise);
	V(in2[11]) <+ transition(($abstime >= 27n + T_dur && $abstime < 27n + Twrite_dur) ?
                    ((row27_value_right >> 11) & 1 ? v_high : v_low) : v_low, 0, trise);
	V(in1[12]) <+ transition(($abstime >= 27n + T_dur && $abstime < 27n + Twrite_dur) ?
                    ((row27_value_left >> 12) & 1 ? v_high : v_low) : v_low, 0, trise);
	V(in2[12]) <+ transition(($abstime >= 27n + T_dur && $abstime < 27n + Twrite_dur) ?
                    ((row27_value_right >> 12) & 1 ? v_high : v_low) : v_low, 0, trise);
	V(in1[13]) <+ transition(($abstime >= 27n + T_dur && $abstime < 27n + Twrite_dur) ?
                    ((row27_value_left >> 13) & 1 ? v_high : v_low) : v_low, 0, trise);
	V(in2[13]) <+ transition(($abstime >= 27n + T_dur && $abstime < 27n + Twrite_dur) ?
                    ((row27_value_right >> 13) & 1 ? v_high : v_low) : v_low, 0, trise);
	V(in1[14]) <+ transition(($abstime >= 27n + T_dur && $abstime < 27n + Twrite_dur) ?
                    ((row27_value_left >> 14) & 1 ? v_high : v_low) : v_low, 0, trise);
	V(in2[14]) <+ transition(($abstime >= 27n + T_dur && $abstime < 27n + Twrite_dur) ?
                    ((row27_value_right >> 14) & 1 ? v_high : v_low) : v_low, 0, trise);
	V(in1[15]) <+ transition(($abstime >= 27n + T_dur && $abstime < 27n + Twrite_dur) ?
                    ((row27_value_left >> 15) & 1 ? v_high : v_low) : v_low, 0, trise);
	V(in2[15]) <+ transition(($abstime >= 27n + T_dur && $abstime < 27n + Twrite_dur) ?
                    ((row27_value_right >> 15) & 1 ? v_high : v_low) : v_low, 0, trise);
	V(in1[16]) <+ transition(($abstime >= 27n + T_dur && $abstime < 27n + Twrite_dur) ?
                    ((row27_value_left >> 16) & 1 ? v_high : v_low) : v_low, 0, trise);
	V(in2[16]) <+ transition(($abstime >= 27n + T_dur && $abstime < 27n + Twrite_dur) ?
                    ((row27_value_right >> 16) & 1 ? v_high : v_low) : v_low, 0, trise);
	V(in1[17]) <+ transition(($abstime >= 27n + T_dur && $abstime < 27n + Twrite_dur) ?
                    ((row27_value_left >> 17) & 1 ? v_high : v_low) : v_low, 0, trise);
	V(in2[17]) <+ transition(($abstime >= 27n + T_dur && $abstime < 27n + Twrite_dur) ?
                    ((row27_value_right >> 17) & 1 ? v_high : v_low) : v_low, 0, trise);
	V(in1[18]) <+ transition(($abstime >= 27n + T_dur && $abstime < 27n + Twrite_dur) ?
                    ((row27_value_left >> 18) & 1 ? v_high : v_low) : v_low, 0, trise);
	V(in2[18]) <+ transition(($abstime >= 27n + T_dur && $abstime < 27n + Twrite_dur) ?
                    ((row27_value_right >> 18) & 1 ? v_high : v_low) : v_low, 0, trise);
	V(in1[19]) <+ transition(($abstime >= 27n + T_dur && $abstime < 27n + Twrite_dur) ?
                    ((row27_value_left >> 19) & 1 ? v_high : v_low) : v_low, 0, trise);
	V(in2[19]) <+ transition(($abstime >= 27n + T_dur && $abstime < 27n + Twrite_dur) ?
                    ((row27_value_right >> 19) & 1 ? v_high : v_low) : v_low, 0, trise);
	V(in1[20]) <+ transition(($abstime >= 27n + T_dur && $abstime < 27n + Twrite_dur) ?
                    ((row27_value_left >> 20) & 1 ? v_high : v_low) : v_low, 0, trise);
	V(in2[20]) <+ transition(($abstime >= 27n + T_dur && $abstime < 27n + Twrite_dur) ?
                    ((row27_value_right >> 20) & 1 ? v_high : v_low) : v_low, 0, trise);
	V(in1[21]) <+ transition(($abstime >= 27n + T_dur && $abstime < 27n + Twrite_dur) ?
                    ((row27_value_left >> 21) & 1 ? v_high : v_low) : v_low, 0, trise);
	V(in2[21]) <+ transition(($abstime >= 27n + T_dur && $abstime < 27n + Twrite_dur) ?
                    ((row27_value_right >> 21) & 1 ? v_high : v_low) : v_low, 0, trise);
	V(in1[22]) <+ transition(($abstime >= 27n + T_dur && $abstime < 27n + Twrite_dur) ?
                    ((row27_value_left >> 22) & 1 ? v_high : v_low) : v_low, 0, trise);
	V(in2[22]) <+ transition(($abstime >= 27n + T_dur && $abstime < 27n + Twrite_dur) ?
                    ((row27_value_right >> 22) & 1 ? v_high : v_low) : v_low, 0, trise);
	V(in1[23]) <+ transition(($abstime >= 27n + T_dur && $abstime < 27n + Twrite_dur) ?
                    ((row27_value_left >> 23) & 1 ? v_high : v_low) : v_low, 0, trise);
	V(in2[23]) <+ transition(($abstime >= 27n + T_dur && $abstime < 27n + Twrite_dur) ?
                    ((row27_value_right >> 23) & 1 ? v_high : v_low) : v_low, 0, trise);
	V(in1[24]) <+ transition(($abstime >= 27n + T_dur && $abstime < 27n + Twrite_dur) ?
                    ((row27_value_left >> 24) & 1 ? v_high : v_low) : v_low, 0, trise);
	V(in2[24]) <+ transition(($abstime >= 27n + T_dur && $abstime < 27n + Twrite_dur) ?
                    ((row27_value_right >> 24) & 1 ? v_high : v_low) : v_low, 0, trise);
	V(in1[25]) <+ transition(($abstime >= 27n + T_dur && $abstime < 27n + Twrite_dur) ?
                    ((row27_value_left >> 25) & 1 ? v_high : v_low) : v_low, 0, trise);
	V(in2[25]) <+ transition(($abstime >= 27n + T_dur && $abstime < 27n + Twrite_dur) ?
                    ((row27_value_right >> 25) & 1 ? v_high : v_low) : v_low, 0, trise);
	V(in1[26]) <+ transition(($abstime >= 27n + T_dur && $abstime < 27n + Twrite_dur) ?
                    ((row27_value_left >> 26) & 1 ? v_high : v_low) : v_low, 0, trise);
	V(in2[26]) <+ transition(($abstime >= 27n + T_dur && $abstime < 27n + Twrite_dur) ?
                    ((row27_value_right >> 26) & 1 ? v_high : v_low) : v_low, 0, trise);
	V(in1[27]) <+ transition(($abstime >= 27n + T_dur && $abstime < 27n + Twrite_dur) ?
                    ((row27_value_left >> 27) & 1 ? v_high : v_low) : v_low, 0, trise);
	V(in2[27]) <+ transition(($abstime >= 27n + T_dur && $abstime < 27n + Twrite_dur) ?
                    ((row27_value_right >> 27) & 1 ? v_high : v_low) : v_low, 0, trise);
	V(in1[28]) <+ transition(($abstime >= 27n + T_dur && $abstime < 27n + Twrite_dur) ?
                    ((row27_value_left >> 28) & 1 ? v_high : v_low) : v_low, 0, trise);
	V(in2[28]) <+ transition(($abstime >= 27n + T_dur && $abstime < 27n + Twrite_dur) ?
                    ((row27_value_right >> 28) & 1 ? v_high : v_low) : v_low, 0, trise);
	V(in1[29]) <+ transition(($abstime >= 27n + T_dur && $abstime < 27n + Twrite_dur) ?
                    ((row27_value_left >> 29) & 1 ? v_high : v_low) : v_low, 0, trise);
	V(in2[29]) <+ transition(($abstime >= 27n + T_dur && $abstime < 27n + Twrite_dur) ?
                    ((row27_value_right >> 29) & 1 ? v_high : v_low) : v_low, 0, trise);
	V(in1[30]) <+ transition(($abstime >= 27n + T_dur && $abstime < 27n + Twrite_dur) ?
                    ((row27_value_left >> 30) & 1 ? v_high : v_low) : v_low, 0, trise);
	V(in2[30]) <+ transition(($abstime >= 27n + T_dur && $abstime < 27n + Twrite_dur) ?
                    ((row27_value_right >> 30) & 1 ? v_high : v_low) : v_low, 0, trise);
	V(in1[31]) <+ transition(($abstime >= 27n + T_dur && $abstime < 27n + Twrite_dur) ?
                    ((row27_value_left >> 31) & 1 ? v_high : v_low) : v_low, 0, trise);
	V(in2[31]) <+ transition(($abstime >= 27n + T_dur && $abstime < 27n + Twrite_dur) ?
                    ((row27_value_right >> 31) & 1 ? v_high : v_low) : v_low, 0, trise);

    V(write) <+ transition(($abstime >= 28n + T_dur && $abstime < 28n + Twrite_dur) ? v_high : v_low, 0, trise);
    V(WL[28]) <+ transition(($abstime >= 28n + T_dur && $abstime < 28n + TWL_dur) ? v_high : v_low, 0, trise);
	V(in1[0]) <+ transition(($abstime >= 28n + T_dur && $abstime < 28n + Twrite_dur) ?
                    ((row28_value_left >> 0) & 1 ? v_high : v_low) : v_low, 0, trise);
	V(in2[0]) <+ transition(($abstime >= 28n + T_dur && $abstime < 28n + Twrite_dur) ?
                    ((row28_value_right >> 0) & 1 ? v_high : v_low) : v_low, 0, trise);
	V(in1[1]) <+ transition(($abstime >= 28n + T_dur && $abstime < 28n + Twrite_dur) ?
                    ((row28_value_left >> 1) & 1 ? v_high : v_low) : v_low, 0, trise);
	V(in2[1]) <+ transition(($abstime >= 28n + T_dur && $abstime < 28n + Twrite_dur) ?
                    ((row28_value_right >> 1) & 1 ? v_high : v_low) : v_low, 0, trise);
	V(in1[2]) <+ transition(($abstime >= 28n + T_dur && $abstime < 28n + Twrite_dur) ?
                    ((row28_value_left >> 2) & 1 ? v_high : v_low) : v_low, 0, trise);
	V(in2[2]) <+ transition(($abstime >= 28n + T_dur && $abstime < 28n + Twrite_dur) ?
                    ((row28_value_right >> 2) & 1 ? v_high : v_low) : v_low, 0, trise);
	V(in1[3]) <+ transition(($abstime >= 28n + T_dur && $abstime < 28n + Twrite_dur) ?
                    ((row28_value_left >> 3) & 1 ? v_high : v_low) : v_low, 0, trise);
	V(in2[3]) <+ transition(($abstime >= 28n + T_dur && $abstime < 28n + Twrite_dur) ?
                    ((row28_value_right >> 3) & 1 ? v_high : v_low) : v_low, 0, trise);
	V(in1[4]) <+ transition(($abstime >= 28n + T_dur && $abstime < 28n + Twrite_dur) ?
                    ((row28_value_left >> 4) & 1 ? v_high : v_low) : v_low, 0, trise);
	V(in2[4]) <+ transition(($abstime >= 28n + T_dur && $abstime < 28n + Twrite_dur) ?
                    ((row28_value_right >> 4) & 1 ? v_high : v_low) : v_low, 0, trise);
	V(in1[5]) <+ transition(($abstime >= 28n + T_dur && $abstime < 28n + Twrite_dur) ?
                    ((row28_value_left >> 5) & 1 ? v_high : v_low) : v_low, 0, trise);
	V(in2[5]) <+ transition(($abstime >= 28n + T_dur && $abstime < 28n + Twrite_dur) ?
                    ((row28_value_right >> 5) & 1 ? v_high : v_low) : v_low, 0, trise);
	V(in1[6]) <+ transition(($abstime >= 28n + T_dur && $abstime < 28n + Twrite_dur) ?
                    ((row28_value_left >> 6) & 1 ? v_high : v_low) : v_low, 0, trise);
	V(in2[6]) <+ transition(($abstime >= 28n + T_dur && $abstime < 28n + Twrite_dur) ?
                    ((row28_value_right >> 6) & 1 ? v_high : v_low) : v_low, 0, trise);
	V(in1[7]) <+ transition(($abstime >= 28n + T_dur && $abstime < 28n + Twrite_dur) ?
                    ((row28_value_left >> 7) & 1 ? v_high : v_low) : v_low, 0, trise);
	V(in2[7]) <+ transition(($abstime >= 28n + T_dur && $abstime < 28n + Twrite_dur) ?
                    ((row28_value_right >> 7) & 1 ? v_high : v_low) : v_low, 0, trise);
	V(in1[8]) <+ transition(($abstime >= 28n + T_dur && $abstime < 28n + Twrite_dur) ?
                    ((row28_value_left >> 8) & 1 ? v_high : v_low) : v_low, 0, trise);
	V(in2[8]) <+ transition(($abstime >= 28n + T_dur && $abstime < 28n + Twrite_dur) ?
                    ((row28_value_right >> 8) & 1 ? v_high : v_low) : v_low, 0, trise);
	V(in1[9]) <+ transition(($abstime >= 28n + T_dur && $abstime < 28n + Twrite_dur) ?
                    ((row28_value_left >> 9) & 1 ? v_high : v_low) : v_low, 0, trise);
	V(in2[9]) <+ transition(($abstime >= 28n + T_dur && $abstime < 28n + Twrite_dur) ?
                    ((row28_value_right >> 9) & 1 ? v_high : v_low) : v_low, 0, trise);
	V(in1[10]) <+ transition(($abstime >= 28n + T_dur && $abstime < 28n + Twrite_dur) ?
                    ((row28_value_left >> 10) & 1 ? v_high : v_low) : v_low, 0, trise);
	V(in2[10]) <+ transition(($abstime >= 28n + T_dur && $abstime < 28n + Twrite_dur) ?
                    ((row28_value_right >> 10) & 1 ? v_high : v_low) : v_low, 0, trise);
	V(in1[11]) <+ transition(($abstime >= 28n + T_dur && $abstime < 28n + Twrite_dur) ?
                    ((row28_value_left >> 11) & 1 ? v_high : v_low) : v_low, 0, trise);
	V(in2[11]) <+ transition(($abstime >= 28n + T_dur && $abstime < 28n + Twrite_dur) ?
                    ((row28_value_right >> 11) & 1 ? v_high : v_low) : v_low, 0, trise);
	V(in1[12]) <+ transition(($abstime >= 28n + T_dur && $abstime < 28n + Twrite_dur) ?
                    ((row28_value_left >> 12) & 1 ? v_high : v_low) : v_low, 0, trise);
	V(in2[12]) <+ transition(($abstime >= 28n + T_dur && $abstime < 28n + Twrite_dur) ?
                    ((row28_value_right >> 12) & 1 ? v_high : v_low) : v_low, 0, trise);
	V(in1[13]) <+ transition(($abstime >= 28n + T_dur && $abstime < 28n + Twrite_dur) ?
                    ((row28_value_left >> 13) & 1 ? v_high : v_low) : v_low, 0, trise);
	V(in2[13]) <+ transition(($abstime >= 28n + T_dur && $abstime < 28n + Twrite_dur) ?
                    ((row28_value_right >> 13) & 1 ? v_high : v_low) : v_low, 0, trise);
	V(in1[14]) <+ transition(($abstime >= 28n + T_dur && $abstime < 28n + Twrite_dur) ?
                    ((row28_value_left >> 14) & 1 ? v_high : v_low) : v_low, 0, trise);
	V(in2[14]) <+ transition(($abstime >= 28n + T_dur && $abstime < 28n + Twrite_dur) ?
                    ((row28_value_right >> 14) & 1 ? v_high : v_low) : v_low, 0, trise);
	V(in1[15]) <+ transition(($abstime >= 28n + T_dur && $abstime < 28n + Twrite_dur) ?
                    ((row28_value_left >> 15) & 1 ? v_high : v_low) : v_low, 0, trise);
	V(in2[15]) <+ transition(($abstime >= 28n + T_dur && $abstime < 28n + Twrite_dur) ?
                    ((row28_value_right >> 15) & 1 ? v_high : v_low) : v_low, 0, trise);
	V(in1[16]) <+ transition(($abstime >= 28n + T_dur && $abstime < 28n + Twrite_dur) ?
                    ((row28_value_left >> 16) & 1 ? v_high : v_low) : v_low, 0, trise);
	V(in2[16]) <+ transition(($abstime >= 28n + T_dur && $abstime < 28n + Twrite_dur) ?
                    ((row28_value_right >> 16) & 1 ? v_high : v_low) : v_low, 0, trise);
	V(in1[17]) <+ transition(($abstime >= 28n + T_dur && $abstime < 28n + Twrite_dur) ?
                    ((row28_value_left >> 17) & 1 ? v_high : v_low) : v_low, 0, trise);
	V(in2[17]) <+ transition(($abstime >= 28n + T_dur && $abstime < 28n + Twrite_dur) ?
                    ((row28_value_right >> 17) & 1 ? v_high : v_low) : v_low, 0, trise);
	V(in1[18]) <+ transition(($abstime >= 28n + T_dur && $abstime < 28n + Twrite_dur) ?
                    ((row28_value_left >> 18) & 1 ? v_high : v_low) : v_low, 0, trise);
	V(in2[18]) <+ transition(($abstime >= 28n + T_dur && $abstime < 28n + Twrite_dur) ?
                    ((row28_value_right >> 18) & 1 ? v_high : v_low) : v_low, 0, trise);
	V(in1[19]) <+ transition(($abstime >= 28n + T_dur && $abstime < 28n + Twrite_dur) ?
                    ((row28_value_left >> 19) & 1 ? v_high : v_low) : v_low, 0, trise);
	V(in2[19]) <+ transition(($abstime >= 28n + T_dur && $abstime < 28n + Twrite_dur) ?
                    ((row28_value_right >> 19) & 1 ? v_high : v_low) : v_low, 0, trise);
	V(in1[20]) <+ transition(($abstime >= 28n + T_dur && $abstime < 28n + Twrite_dur) ?
                    ((row28_value_left >> 20) & 1 ? v_high : v_low) : v_low, 0, trise);
	V(in2[20]) <+ transition(($abstime >= 28n + T_dur && $abstime < 28n + Twrite_dur) ?
                    ((row28_value_right >> 20) & 1 ? v_high : v_low) : v_low, 0, trise);
	V(in1[21]) <+ transition(($abstime >= 28n + T_dur && $abstime < 28n + Twrite_dur) ?
                    ((row28_value_left >> 21) & 1 ? v_high : v_low) : v_low, 0, trise);
	V(in2[21]) <+ transition(($abstime >= 28n + T_dur && $abstime < 28n + Twrite_dur) ?
                    ((row28_value_right >> 21) & 1 ? v_high : v_low) : v_low, 0, trise);
	V(in1[22]) <+ transition(($abstime >= 28n + T_dur && $abstime < 28n + Twrite_dur) ?
                    ((row28_value_left >> 22) & 1 ? v_high : v_low) : v_low, 0, trise);
	V(in2[22]) <+ transition(($abstime >= 28n + T_dur && $abstime < 28n + Twrite_dur) ?
                    ((row28_value_right >> 22) & 1 ? v_high : v_low) : v_low, 0, trise);
	V(in1[23]) <+ transition(($abstime >= 28n + T_dur && $abstime < 28n + Twrite_dur) ?
                    ((row28_value_left >> 23) & 1 ? v_high : v_low) : v_low, 0, trise);
	V(in2[23]) <+ transition(($abstime >= 28n + T_dur && $abstime < 28n + Twrite_dur) ?
                    ((row28_value_right >> 23) & 1 ? v_high : v_low) : v_low, 0, trise);
	V(in1[24]) <+ transition(($abstime >= 28n + T_dur && $abstime < 28n + Twrite_dur) ?
                    ((row28_value_left >> 24) & 1 ? v_high : v_low) : v_low, 0, trise);
	V(in2[24]) <+ transition(($abstime >= 28n + T_dur && $abstime < 28n + Twrite_dur) ?
                    ((row28_value_right >> 24) & 1 ? v_high : v_low) : v_low, 0, trise);
	V(in1[25]) <+ transition(($abstime >= 28n + T_dur && $abstime < 28n + Twrite_dur) ?
                    ((row28_value_left >> 25) & 1 ? v_high : v_low) : v_low, 0, trise);
	V(in2[25]) <+ transition(($abstime >= 28n + T_dur && $abstime < 28n + Twrite_dur) ?
                    ((row28_value_right >> 25) & 1 ? v_high : v_low) : v_low, 0, trise);
	V(in1[26]) <+ transition(($abstime >= 28n + T_dur && $abstime < 28n + Twrite_dur) ?
                    ((row28_value_left >> 26) & 1 ? v_high : v_low) : v_low, 0, trise);
	V(in2[26]) <+ transition(($abstime >= 28n + T_dur && $abstime < 28n + Twrite_dur) ?
                    ((row28_value_right >> 26) & 1 ? v_high : v_low) : v_low, 0, trise);
	V(in1[27]) <+ transition(($abstime >= 28n + T_dur && $abstime < 28n + Twrite_dur) ?
                    ((row28_value_left >> 27) & 1 ? v_high : v_low) : v_low, 0, trise);
	V(in2[27]) <+ transition(($abstime >= 28n + T_dur && $abstime < 28n + Twrite_dur) ?
                    ((row28_value_right >> 27) & 1 ? v_high : v_low) : v_low, 0, trise);
	V(in1[28]) <+ transition(($abstime >= 28n + T_dur && $abstime < 28n + Twrite_dur) ?
                    ((row28_value_left >> 28) & 1 ? v_high : v_low) : v_low, 0, trise);
	V(in2[28]) <+ transition(($abstime >= 28n + T_dur && $abstime < 28n + Twrite_dur) ?
                    ((row28_value_right >> 28) & 1 ? v_high : v_low) : v_low, 0, trise);
	V(in1[29]) <+ transition(($abstime >= 28n + T_dur && $abstime < 28n + Twrite_dur) ?
                    ((row28_value_left >> 29) & 1 ? v_high : v_low) : v_low, 0, trise);
	V(in2[29]) <+ transition(($abstime >= 28n + T_dur && $abstime < 28n + Twrite_dur) ?
                    ((row28_value_right >> 29) & 1 ? v_high : v_low) : v_low, 0, trise);
	V(in1[30]) <+ transition(($abstime >= 28n + T_dur && $abstime < 28n + Twrite_dur) ?
                    ((row28_value_left >> 30) & 1 ? v_high : v_low) : v_low, 0, trise);
	V(in2[30]) <+ transition(($abstime >= 28n + T_dur && $abstime < 28n + Twrite_dur) ?
                    ((row28_value_right >> 30) & 1 ? v_high : v_low) : v_low, 0, trise);
	V(in1[31]) <+ transition(($abstime >= 28n + T_dur && $abstime < 28n + Twrite_dur) ?
                    ((row28_value_left >> 31) & 1 ? v_high : v_low) : v_low, 0, trise);
	V(in2[31]) <+ transition(($abstime >= 28n + T_dur && $abstime < 28n + Twrite_dur) ?
                    ((row28_value_right >> 31) & 1 ? v_high : v_low) : v_low, 0, trise);

    V(write) <+ transition(($abstime >= 29n + T_dur && $abstime < 29n + Twrite_dur) ? v_high : v_low, 0, trise);
    V(WL[29]) <+ transition(($abstime >= 29n + T_dur && $abstime < 29n + TWL_dur) ? v_high : v_low, 0, trise);
	V(in1[0]) <+ transition(($abstime >= 29n + T_dur && $abstime < 29n + Twrite_dur) ?
                    ((row29_value_left >> 0) & 1 ? v_high : v_low) : v_low, 0, trise);
	V(in2[0]) <+ transition(($abstime >= 29n + T_dur && $abstime < 29n + Twrite_dur) ?
                    ((row29_value_right >> 0) & 1 ? v_high : v_low) : v_low, 0, trise);
	V(in1[1]) <+ transition(($abstime >= 29n + T_dur && $abstime < 29n + Twrite_dur) ?
                    ((row29_value_left >> 1) & 1 ? v_high : v_low) : v_low, 0, trise);
	V(in2[1]) <+ transition(($abstime >= 29n + T_dur && $abstime < 29n + Twrite_dur) ?
                    ((row29_value_right >> 1) & 1 ? v_high : v_low) : v_low, 0, trise);
	V(in1[2]) <+ transition(($abstime >= 29n + T_dur && $abstime < 29n + Twrite_dur) ?
                    ((row29_value_left >> 2) & 1 ? v_high : v_low) : v_low, 0, trise);
	V(in2[2]) <+ transition(($abstime >= 29n + T_dur && $abstime < 29n + Twrite_dur) ?
                    ((row29_value_right >> 2) & 1 ? v_high : v_low) : v_low, 0, trise);
	V(in1[3]) <+ transition(($abstime >= 29n + T_dur && $abstime < 29n + Twrite_dur) ?
                    ((row29_value_left >> 3) & 1 ? v_high : v_low) : v_low, 0, trise);
	V(in2[3]) <+ transition(($abstime >= 29n + T_dur && $abstime < 29n + Twrite_dur) ?
                    ((row29_value_right >> 3) & 1 ? v_high : v_low) : v_low, 0, trise);
	V(in1[4]) <+ transition(($abstime >= 29n + T_dur && $abstime < 29n + Twrite_dur) ?
                    ((row29_value_left >> 4) & 1 ? v_high : v_low) : v_low, 0, trise);
	V(in2[4]) <+ transition(($abstime >= 29n + T_dur && $abstime < 29n + Twrite_dur) ?
                    ((row29_value_right >> 4) & 1 ? v_high : v_low) : v_low, 0, trise);
	V(in1[5]) <+ transition(($abstime >= 29n + T_dur && $abstime < 29n + Twrite_dur) ?
                    ((row29_value_left >> 5) & 1 ? v_high : v_low) : v_low, 0, trise);
	V(in2[5]) <+ transition(($abstime >= 29n + T_dur && $abstime < 29n + Twrite_dur) ?
                    ((row29_value_right >> 5) & 1 ? v_high : v_low) : v_low, 0, trise);
	V(in1[6]) <+ transition(($abstime >= 29n + T_dur && $abstime < 29n + Twrite_dur) ?
                    ((row29_value_left >> 6) & 1 ? v_high : v_low) : v_low, 0, trise);
	V(in2[6]) <+ transition(($abstime >= 29n + T_dur && $abstime < 29n + Twrite_dur) ?
                    ((row29_value_right >> 6) & 1 ? v_high : v_low) : v_low, 0, trise);
	V(in1[7]) <+ transition(($abstime >= 29n + T_dur && $abstime < 29n + Twrite_dur) ?
                    ((row29_value_left >> 7) & 1 ? v_high : v_low) : v_low, 0, trise);
	V(in2[7]) <+ transition(($abstime >= 29n + T_dur && $abstime < 29n + Twrite_dur) ?
                    ((row29_value_right >> 7) & 1 ? v_high : v_low) : v_low, 0, trise);
	V(in1[8]) <+ transition(($abstime >= 29n + T_dur && $abstime < 29n + Twrite_dur) ?
                    ((row29_value_left >> 8) & 1 ? v_high : v_low) : v_low, 0, trise);
	V(in2[8]) <+ transition(($abstime >= 29n + T_dur && $abstime < 29n + Twrite_dur) ?
                    ((row29_value_right >> 8) & 1 ? v_high : v_low) : v_low, 0, trise);
	V(in1[9]) <+ transition(($abstime >= 29n + T_dur && $abstime < 29n + Twrite_dur) ?
                    ((row29_value_left >> 9) & 1 ? v_high : v_low) : v_low, 0, trise);
	V(in2[9]) <+ transition(($abstime >= 29n + T_dur && $abstime < 29n + Twrite_dur) ?
                    ((row29_value_right >> 9) & 1 ? v_high : v_low) : v_low, 0, trise);
	V(in1[10]) <+ transition(($abstime >= 29n + T_dur && $abstime < 29n + Twrite_dur) ?
                    ((row29_value_left >> 10) & 1 ? v_high : v_low) : v_low, 0, trise);
	V(in2[10]) <+ transition(($abstime >= 29n + T_dur && $abstime < 29n + Twrite_dur) ?
                    ((row29_value_right >> 10) & 1 ? v_high : v_low) : v_low, 0, trise);
	V(in1[11]) <+ transition(($abstime >= 29n + T_dur && $abstime < 29n + Twrite_dur) ?
                    ((row29_value_left >> 11) & 1 ? v_high : v_low) : v_low, 0, trise);
	V(in2[11]) <+ transition(($abstime >= 29n + T_dur && $abstime < 29n + Twrite_dur) ?
                    ((row29_value_right >> 11) & 1 ? v_high : v_low) : v_low, 0, trise);
	V(in1[12]) <+ transition(($abstime >= 29n + T_dur && $abstime < 29n + Twrite_dur) ?
                    ((row29_value_left >> 12) & 1 ? v_high : v_low) : v_low, 0, trise);
	V(in2[12]) <+ transition(($abstime >= 29n + T_dur && $abstime < 29n + Twrite_dur) ?
                    ((row29_value_right >> 12) & 1 ? v_high : v_low) : v_low, 0, trise);
	V(in1[13]) <+ transition(($abstime >= 29n + T_dur && $abstime < 29n + Twrite_dur) ?
                    ((row29_value_left >> 13) & 1 ? v_high : v_low) : v_low, 0, trise);
	V(in2[13]) <+ transition(($abstime >= 29n + T_dur && $abstime < 29n + Twrite_dur) ?
                    ((row29_value_right >> 13) & 1 ? v_high : v_low) : v_low, 0, trise);
	V(in1[14]) <+ transition(($abstime >= 29n + T_dur && $abstime < 29n + Twrite_dur) ?
                    ((row29_value_left >> 14) & 1 ? v_high : v_low) : v_low, 0, trise);
	V(in2[14]) <+ transition(($abstime >= 29n + T_dur && $abstime < 29n + Twrite_dur) ?
                    ((row29_value_right >> 14) & 1 ? v_high : v_low) : v_low, 0, trise);
	V(in1[15]) <+ transition(($abstime >= 29n + T_dur && $abstime < 29n + Twrite_dur) ?
                    ((row29_value_left >> 15) & 1 ? v_high : v_low) : v_low, 0, trise);
	V(in2[15]) <+ transition(($abstime >= 29n + T_dur && $abstime < 29n + Twrite_dur) ?
                    ((row29_value_right >> 15) & 1 ? v_high : v_low) : v_low, 0, trise);
	V(in1[16]) <+ transition(($abstime >= 29n + T_dur && $abstime < 29n + Twrite_dur) ?
                    ((row29_value_left >> 16) & 1 ? v_high : v_low) : v_low, 0, trise);
	V(in2[16]) <+ transition(($abstime >= 29n + T_dur && $abstime < 29n + Twrite_dur) ?
                    ((row29_value_right >> 16) & 1 ? v_high : v_low) : v_low, 0, trise);
	V(in1[17]) <+ transition(($abstime >= 29n + T_dur && $abstime < 29n + Twrite_dur) ?
                    ((row29_value_left >> 17) & 1 ? v_high : v_low) : v_low, 0, trise);
	V(in2[17]) <+ transition(($abstime >= 29n + T_dur && $abstime < 29n + Twrite_dur) ?
                    ((row29_value_right >> 17) & 1 ? v_high : v_low) : v_low, 0, trise);
	V(in1[18]) <+ transition(($abstime >= 29n + T_dur && $abstime < 29n + Twrite_dur) ?
                    ((row29_value_left >> 18) & 1 ? v_high : v_low) : v_low, 0, trise);
	V(in2[18]) <+ transition(($abstime >= 29n + T_dur && $abstime < 29n + Twrite_dur) ?
                    ((row29_value_right >> 18) & 1 ? v_high : v_low) : v_low, 0, trise);
	V(in1[19]) <+ transition(($abstime >= 29n + T_dur && $abstime < 29n + Twrite_dur) ?
                    ((row29_value_left >> 19) & 1 ? v_high : v_low) : v_low, 0, trise);
	V(in2[19]) <+ transition(($abstime >= 29n + T_dur && $abstime < 29n + Twrite_dur) ?
                    ((row29_value_right >> 19) & 1 ? v_high : v_low) : v_low, 0, trise);
	V(in1[20]) <+ transition(($abstime >= 29n + T_dur && $abstime < 29n + Twrite_dur) ?
                    ((row29_value_left >> 20) & 1 ? v_high : v_low) : v_low, 0, trise);
	V(in2[20]) <+ transition(($abstime >= 29n + T_dur && $abstime < 29n + Twrite_dur) ?
                    ((row29_value_right >> 20) & 1 ? v_high : v_low) : v_low, 0, trise);
	V(in1[21]) <+ transition(($abstime >= 29n + T_dur && $abstime < 29n + Twrite_dur) ?
                    ((row29_value_left >> 21) & 1 ? v_high : v_low) : v_low, 0, trise);
	V(in2[21]) <+ transition(($abstime >= 29n + T_dur && $abstime < 29n + Twrite_dur) ?
                    ((row29_value_right >> 21) & 1 ? v_high : v_low) : v_low, 0, trise);
	V(in1[22]) <+ transition(($abstime >= 29n + T_dur && $abstime < 29n + Twrite_dur) ?
                    ((row29_value_left >> 22) & 1 ? v_high : v_low) : v_low, 0, trise);
	V(in2[22]) <+ transition(($abstime >= 29n + T_dur && $abstime < 29n + Twrite_dur) ?
                    ((row29_value_right >> 22) & 1 ? v_high : v_low) : v_low, 0, trise);
	V(in1[23]) <+ transition(($abstime >= 29n + T_dur && $abstime < 29n + Twrite_dur) ?
                    ((row29_value_left >> 23) & 1 ? v_high : v_low) : v_low, 0, trise);
	V(in2[23]) <+ transition(($abstime >= 29n + T_dur && $abstime < 29n + Twrite_dur) ?
                    ((row29_value_right >> 23) & 1 ? v_high : v_low) : v_low, 0, trise);
	V(in1[24]) <+ transition(($abstime >= 29n + T_dur && $abstime < 29n + Twrite_dur) ?
                    ((row29_value_left >> 24) & 1 ? v_high : v_low) : v_low, 0, trise);
	V(in2[24]) <+ transition(($abstime >= 29n + T_dur && $abstime < 29n + Twrite_dur) ?
                    ((row29_value_right >> 24) & 1 ? v_high : v_low) : v_low, 0, trise);
	V(in1[25]) <+ transition(($abstime >= 29n + T_dur && $abstime < 29n + Twrite_dur) ?
                    ((row29_value_left >> 25) & 1 ? v_high : v_low) : v_low, 0, trise);
	V(in2[25]) <+ transition(($abstime >= 29n + T_dur && $abstime < 29n + Twrite_dur) ?
                    ((row29_value_right >> 25) & 1 ? v_high : v_low) : v_low, 0, trise);
	V(in1[26]) <+ transition(($abstime >= 29n + T_dur && $abstime < 29n + Twrite_dur) ?
                    ((row29_value_left >> 26) & 1 ? v_high : v_low) : v_low, 0, trise);
	V(in2[26]) <+ transition(($abstime >= 29n + T_dur && $abstime < 29n + Twrite_dur) ?
                    ((row29_value_right >> 26) & 1 ? v_high : v_low) : v_low, 0, trise);
	V(in1[27]) <+ transition(($abstime >= 29n + T_dur && $abstime < 29n + Twrite_dur) ?
                    ((row29_value_left >> 27) & 1 ? v_high : v_low) : v_low, 0, trise);
	V(in2[27]) <+ transition(($abstime >= 29n + T_dur && $abstime < 29n + Twrite_dur) ?
                    ((row29_value_right >> 27) & 1 ? v_high : v_low) : v_low, 0, trise);
	V(in1[28]) <+ transition(($abstime >= 29n + T_dur && $abstime < 29n + Twrite_dur) ?
                    ((row29_value_left >> 28) & 1 ? v_high : v_low) : v_low, 0, trise);
	V(in2[28]) <+ transition(($abstime >= 29n + T_dur && $abstime < 29n + Twrite_dur) ?
                    ((row29_value_right >> 28) & 1 ? v_high : v_low) : v_low, 0, trise);
	V(in1[29]) <+ transition(($abstime >= 29n + T_dur && $abstime < 29n + Twrite_dur) ?
                    ((row29_value_left >> 29) & 1 ? v_high : v_low) : v_low, 0, trise);
	V(in2[29]) <+ transition(($abstime >= 29n + T_dur && $abstime < 29n + Twrite_dur) ?
                    ((row29_value_right >> 29) & 1 ? v_high : v_low) : v_low, 0, trise);
	V(in1[30]) <+ transition(($abstime >= 29n + T_dur && $abstime < 29n + Twrite_dur) ?
                    ((row29_value_left >> 30) & 1 ? v_high : v_low) : v_low, 0, trise);
	V(in2[30]) <+ transition(($abstime >= 29n + T_dur && $abstime < 29n + Twrite_dur) ?
                    ((row29_value_right >> 30) & 1 ? v_high : v_low) : v_low, 0, trise);
	V(in1[31]) <+ transition(($abstime >= 29n + T_dur && $abstime < 29n + Twrite_dur) ?
                    ((row29_value_left >> 31) & 1 ? v_high : v_low) : v_low, 0, trise);
	V(in2[31]) <+ transition(($abstime >= 29n + T_dur && $abstime < 29n + Twrite_dur) ?
                    ((row29_value_right >> 31) & 1 ? v_high : v_low) : v_low, 0, trise);

    V(write) <+ transition(($abstime >= 30n + T_dur && $abstime < 30n + Twrite_dur) ? v_high : v_low, 0, trise);
    V(WL[30]) <+ transition(($abstime >= 30n + T_dur && $abstime < 30n + TWL_dur) ? v_high : v_low, 0, trise);
	V(in1[0]) <+ transition(($abstime >= 30n + T_dur && $abstime < 30n + Twrite_dur) ?
                    ((row30_value_left >> 0) & 1 ? v_high : v_low) : v_low, 0, trise);
	V(in2[0]) <+ transition(($abstime >= 30n + T_dur && $abstime < 30n + Twrite_dur) ?
                    ((row30_value_right >> 0) & 1 ? v_high : v_low) : v_low, 0, trise);
	V(in1[1]) <+ transition(($abstime >= 30n + T_dur && $abstime < 30n + Twrite_dur) ?
                    ((row30_value_left >> 1) & 1 ? v_high : v_low) : v_low, 0, trise);
	V(in2[1]) <+ transition(($abstime >= 30n + T_dur && $abstime < 30n + Twrite_dur) ?
                    ((row30_value_right >> 1) & 1 ? v_high : v_low) : v_low, 0, trise);
	V(in1[2]) <+ transition(($abstime >= 30n + T_dur && $abstime < 30n + Twrite_dur) ?
                    ((row30_value_left >> 2) & 1 ? v_high : v_low) : v_low, 0, trise);
	V(in2[2]) <+ transition(($abstime >= 30n + T_dur && $abstime < 30n + Twrite_dur) ?
                    ((row30_value_right >> 2) & 1 ? v_high : v_low) : v_low, 0, trise);
	V(in1[3]) <+ transition(($abstime >= 30n + T_dur && $abstime < 30n + Twrite_dur) ?
                    ((row30_value_left >> 3) & 1 ? v_high : v_low) : v_low, 0, trise);
	V(in2[3]) <+ transition(($abstime >= 30n + T_dur && $abstime < 30n + Twrite_dur) ?
                    ((row30_value_right >> 3) & 1 ? v_high : v_low) : v_low, 0, trise);
	V(in1[4]) <+ transition(($abstime >= 30n + T_dur && $abstime < 30n + Twrite_dur) ?
                    ((row30_value_left >> 4) & 1 ? v_high : v_low) : v_low, 0, trise);
	V(in2[4]) <+ transition(($abstime >= 30n + T_dur && $abstime < 30n + Twrite_dur) ?
                    ((row30_value_right >> 4) & 1 ? v_high : v_low) : v_low, 0, trise);
	V(in1[5]) <+ transition(($abstime >= 30n + T_dur && $abstime < 30n + Twrite_dur) ?
                    ((row30_value_left >> 5) & 1 ? v_high : v_low) : v_low, 0, trise);
	V(in2[5]) <+ transition(($abstime >= 30n + T_dur && $abstime < 30n + Twrite_dur) ?
                    ((row30_value_right >> 5) & 1 ? v_high : v_low) : v_low, 0, trise);
	V(in1[6]) <+ transition(($abstime >= 30n + T_dur && $abstime < 30n + Twrite_dur) ?
                    ((row30_value_left >> 6) & 1 ? v_high : v_low) : v_low, 0, trise);
	V(in2[6]) <+ transition(($abstime >= 30n + T_dur && $abstime < 30n + Twrite_dur) ?
                    ((row30_value_right >> 6) & 1 ? v_high : v_low) : v_low, 0, trise);
	V(in1[7]) <+ transition(($abstime >= 30n + T_dur && $abstime < 30n + Twrite_dur) ?
                    ((row30_value_left >> 7) & 1 ? v_high : v_low) : v_low, 0, trise);
	V(in2[7]) <+ transition(($abstime >= 30n + T_dur && $abstime < 30n + Twrite_dur) ?
                    ((row30_value_right >> 7) & 1 ? v_high : v_low) : v_low, 0, trise);
	V(in1[8]) <+ transition(($abstime >= 30n + T_dur && $abstime < 30n + Twrite_dur) ?
                    ((row30_value_left >> 8) & 1 ? v_high : v_low) : v_low, 0, trise);
	V(in2[8]) <+ transition(($abstime >= 30n + T_dur && $abstime < 30n + Twrite_dur) ?
                    ((row30_value_right >> 8) & 1 ? v_high : v_low) : v_low, 0, trise);
	V(in1[9]) <+ transition(($abstime >= 30n + T_dur && $abstime < 30n + Twrite_dur) ?
                    ((row30_value_left >> 9) & 1 ? v_high : v_low) : v_low, 0, trise);
	V(in2[9]) <+ transition(($abstime >= 30n + T_dur && $abstime < 30n + Twrite_dur) ?
                    ((row30_value_right >> 9) & 1 ? v_high : v_low) : v_low, 0, trise);
	V(in1[10]) <+ transition(($abstime >= 30n + T_dur && $abstime < 30n + Twrite_dur) ?
                    ((row30_value_left >> 10) & 1 ? v_high : v_low) : v_low, 0, trise);
	V(in2[10]) <+ transition(($abstime >= 30n + T_dur && $abstime < 30n + Twrite_dur) ?
                    ((row30_value_right >> 10) & 1 ? v_high : v_low) : v_low, 0, trise);
	V(in1[11]) <+ transition(($abstime >= 30n + T_dur && $abstime < 30n + Twrite_dur) ?
                    ((row30_value_left >> 11) & 1 ? v_high : v_low) : v_low, 0, trise);
	V(in2[11]) <+ transition(($abstime >= 30n + T_dur && $abstime < 30n + Twrite_dur) ?
                    ((row30_value_right >> 11) & 1 ? v_high : v_low) : v_low, 0, trise);
	V(in1[12]) <+ transition(($abstime >= 30n + T_dur && $abstime < 30n + Twrite_dur) ?
                    ((row30_value_left >> 12) & 1 ? v_high : v_low) : v_low, 0, trise);
	V(in2[12]) <+ transition(($abstime >= 30n + T_dur && $abstime < 30n + Twrite_dur) ?
                    ((row30_value_right >> 12) & 1 ? v_high : v_low) : v_low, 0, trise);
	V(in1[13]) <+ transition(($abstime >= 30n + T_dur && $abstime < 30n + Twrite_dur) ?
                    ((row30_value_left >> 13) & 1 ? v_high : v_low) : v_low, 0, trise);
	V(in2[13]) <+ transition(($abstime >= 30n + T_dur && $abstime < 30n + Twrite_dur) ?
                    ((row30_value_right >> 13) & 1 ? v_high : v_low) : v_low, 0, trise);
	V(in1[14]) <+ transition(($abstime >= 30n + T_dur && $abstime < 30n + Twrite_dur) ?
                    ((row30_value_left >> 14) & 1 ? v_high : v_low) : v_low, 0, trise);
	V(in2[14]) <+ transition(($abstime >= 30n + T_dur && $abstime < 30n + Twrite_dur) ?
                    ((row30_value_right >> 14) & 1 ? v_high : v_low) : v_low, 0, trise);
	V(in1[15]) <+ transition(($abstime >= 30n + T_dur && $abstime < 30n + Twrite_dur) ?
                    ((row30_value_left >> 15) & 1 ? v_high : v_low) : v_low, 0, trise);
	V(in2[15]) <+ transition(($abstime >= 30n + T_dur && $abstime < 30n + Twrite_dur) ?
                    ((row30_value_right >> 15) & 1 ? v_high : v_low) : v_low, 0, trise);
	V(in1[16]) <+ transition(($abstime >= 30n + T_dur && $abstime < 30n + Twrite_dur) ?
                    ((row30_value_left >> 16) & 1 ? v_high : v_low) : v_low, 0, trise);
	V(in2[16]) <+ transition(($abstime >= 30n + T_dur && $abstime < 30n + Twrite_dur) ?
                    ((row30_value_right >> 16) & 1 ? v_high : v_low) : v_low, 0, trise);
	V(in1[17]) <+ transition(($abstime >= 30n + T_dur && $abstime < 30n + Twrite_dur) ?
                    ((row30_value_left >> 17) & 1 ? v_high : v_low) : v_low, 0, trise);
	V(in2[17]) <+ transition(($abstime >= 30n + T_dur && $abstime < 30n + Twrite_dur) ?
                    ((row30_value_right >> 17) & 1 ? v_high : v_low) : v_low, 0, trise);
	V(in1[18]) <+ transition(($abstime >= 30n + T_dur && $abstime < 30n + Twrite_dur) ?
                    ((row30_value_left >> 18) & 1 ? v_high : v_low) : v_low, 0, trise);
	V(in2[18]) <+ transition(($abstime >= 30n + T_dur && $abstime < 30n + Twrite_dur) ?
                    ((row30_value_right >> 18) & 1 ? v_high : v_low) : v_low, 0, trise);
	V(in1[19]) <+ transition(($abstime >= 30n + T_dur && $abstime < 30n + Twrite_dur) ?
                    ((row30_value_left >> 19) & 1 ? v_high : v_low) : v_low, 0, trise);
	V(in2[19]) <+ transition(($abstime >= 30n + T_dur && $abstime < 30n + Twrite_dur) ?
                    ((row30_value_right >> 19) & 1 ? v_high : v_low) : v_low, 0, trise);
	V(in1[20]) <+ transition(($abstime >= 30n + T_dur && $abstime < 30n + Twrite_dur) ?
                    ((row30_value_left >> 20) & 1 ? v_high : v_low) : v_low, 0, trise);
	V(in2[20]) <+ transition(($abstime >= 30n + T_dur && $abstime < 30n + Twrite_dur) ?
                    ((row30_value_right >> 20) & 1 ? v_high : v_low) : v_low, 0, trise);
	V(in1[21]) <+ transition(($abstime >= 30n + T_dur && $abstime < 30n + Twrite_dur) ?
                    ((row30_value_left >> 21) & 1 ? v_high : v_low) : v_low, 0, trise);
	V(in2[21]) <+ transition(($abstime >= 30n + T_dur && $abstime < 30n + Twrite_dur) ?
                    ((row30_value_right >> 21) & 1 ? v_high : v_low) : v_low, 0, trise);
	V(in1[22]) <+ transition(($abstime >= 30n + T_dur && $abstime < 30n + Twrite_dur) ?
                    ((row30_value_left >> 22) & 1 ? v_high : v_low) : v_low, 0, trise);
	V(in2[22]) <+ transition(($abstime >= 30n + T_dur && $abstime < 30n + Twrite_dur) ?
                    ((row30_value_right >> 22) & 1 ? v_high : v_low) : v_low, 0, trise);
	V(in1[23]) <+ transition(($abstime >= 30n + T_dur && $abstime < 30n + Twrite_dur) ?
                    ((row30_value_left >> 23) & 1 ? v_high : v_low) : v_low, 0, trise);
	V(in2[23]) <+ transition(($abstime >= 30n + T_dur && $abstime < 30n + Twrite_dur) ?
                    ((row30_value_right >> 23) & 1 ? v_high : v_low) : v_low, 0, trise);
	V(in1[24]) <+ transition(($abstime >= 30n + T_dur && $abstime < 30n + Twrite_dur) ?
                    ((row30_value_left >> 24) & 1 ? v_high : v_low) : v_low, 0, trise);
	V(in2[24]) <+ transition(($abstime >= 30n + T_dur && $abstime < 30n + Twrite_dur) ?
                    ((row30_value_right >> 24) & 1 ? v_high : v_low) : v_low, 0, trise);
	V(in1[25]) <+ transition(($abstime >= 30n + T_dur && $abstime < 30n + Twrite_dur) ?
                    ((row30_value_left >> 25) & 1 ? v_high : v_low) : v_low, 0, trise);
	V(in2[25]) <+ transition(($abstime >= 30n + T_dur && $abstime < 30n + Twrite_dur) ?
                    ((row30_value_right >> 25) & 1 ? v_high : v_low) : v_low, 0, trise);
	V(in1[26]) <+ transition(($abstime >= 30n + T_dur && $abstime < 30n + Twrite_dur) ?
                    ((row30_value_left >> 26) & 1 ? v_high : v_low) : v_low, 0, trise);
	V(in2[26]) <+ transition(($abstime >= 30n + T_dur && $abstime < 30n + Twrite_dur) ?
                    ((row30_value_right >> 26) & 1 ? v_high : v_low) : v_low, 0, trise);
	V(in1[27]) <+ transition(($abstime >= 30n + T_dur && $abstime < 30n + Twrite_dur) ?
                    ((row30_value_left >> 27) & 1 ? v_high : v_low) : v_low, 0, trise);
	V(in2[27]) <+ transition(($abstime >= 30n + T_dur && $abstime < 30n + Twrite_dur) ?
                    ((row30_value_right >> 27) & 1 ? v_high : v_low) : v_low, 0, trise);
	V(in1[28]) <+ transition(($abstime >= 30n + T_dur && $abstime < 30n + Twrite_dur) ?
                    ((row30_value_left >> 28) & 1 ? v_high : v_low) : v_low, 0, trise);
	V(in2[28]) <+ transition(($abstime >= 30n + T_dur && $abstime < 30n + Twrite_dur) ?
                    ((row30_value_right >> 28) & 1 ? v_high : v_low) : v_low, 0, trise);
	V(in1[29]) <+ transition(($abstime >= 30n + T_dur && $abstime < 30n + Twrite_dur) ?
                    ((row30_value_left >> 29) & 1 ? v_high : v_low) : v_low, 0, trise);
	V(in2[29]) <+ transition(($abstime >= 30n + T_dur && $abstime < 30n + Twrite_dur) ?
                    ((row30_value_right >> 29) & 1 ? v_high : v_low) : v_low, 0, trise);
	V(in1[30]) <+ transition(($abstime >= 30n + T_dur && $abstime < 30n + Twrite_dur) ?
                    ((row30_value_left >> 30) & 1 ? v_high : v_low) : v_low, 0, trise);
	V(in2[30]) <+ transition(($abstime >= 30n + T_dur && $abstime < 30n + Twrite_dur) ?
                    ((row30_value_right >> 30) & 1 ? v_high : v_low) : v_low, 0, trise);
	V(in1[31]) <+ transition(($abstime >= 30n + T_dur && $abstime < 30n + Twrite_dur) ?
                    ((row30_value_left >> 31) & 1 ? v_high : v_low) : v_low, 0, trise);
	V(in2[31]) <+ transition(($abstime >= 30n + T_dur && $abstime < 30n + Twrite_dur) ?
                    ((row30_value_right >> 31) & 1 ? v_high : v_low) : v_low, 0, trise);

    V(write) <+ transition(($abstime >= 31n + T_dur && $abstime < 31n + Twrite_dur) ? v_high : v_low, 0, trise);
    V(WL[31]) <+ transition(($abstime >= 31n + T_dur && $abstime < 31n + TWL_dur) ? v_high : v_low, 0, trise);
	V(in1[0]) <+ transition(($abstime >= 31n + T_dur && $abstime < 31n + Twrite_dur) ?
                    ((row31_value_left >> 0) & 1 ? v_high : v_low) : v_low, 0, trise);
	V(in2[0]) <+ transition(($abstime >= 31n + T_dur && $abstime < 31n + Twrite_dur) ?
                    ((row31_value_right >> 0) & 1 ? v_high : v_low) : v_low, 0, trise);
	V(in1[1]) <+ transition(($abstime >= 31n + T_dur && $abstime < 31n + Twrite_dur) ?
                    ((row31_value_left >> 1) & 1 ? v_high : v_low) : v_low, 0, trise);
	V(in2[1]) <+ transition(($abstime >= 31n + T_dur && $abstime < 31n + Twrite_dur) ?
                    ((row31_value_right >> 1) & 1 ? v_high : v_low) : v_low, 0, trise);
	V(in1[2]) <+ transition(($abstime >= 31n + T_dur && $abstime < 31n + Twrite_dur) ?
                    ((row31_value_left >> 2) & 1 ? v_high : v_low) : v_low, 0, trise);
	V(in2[2]) <+ transition(($abstime >= 31n + T_dur && $abstime < 31n + Twrite_dur) ?
                    ((row31_value_right >> 2) & 1 ? v_high : v_low) : v_low, 0, trise);
	V(in1[3]) <+ transition(($abstime >= 31n + T_dur && $abstime < 31n + Twrite_dur) ?
                    ((row31_value_left >> 3) & 1 ? v_high : v_low) : v_low, 0, trise);
	V(in2[3]) <+ transition(($abstime >= 31n + T_dur && $abstime < 31n + Twrite_dur) ?
                    ((row31_value_right >> 3) & 1 ? v_high : v_low) : v_low, 0, trise);
	V(in1[4]) <+ transition(($abstime >= 31n + T_dur && $abstime < 31n + Twrite_dur) ?
                    ((row31_value_left >> 4) & 1 ? v_high : v_low) : v_low, 0, trise);
	V(in2[4]) <+ transition(($abstime >= 31n + T_dur && $abstime < 31n + Twrite_dur) ?
                    ((row31_value_right >> 4) & 1 ? v_high : v_low) : v_low, 0, trise);
	V(in1[5]) <+ transition(($abstime >= 31n + T_dur && $abstime < 31n + Twrite_dur) ?
                    ((row31_value_left >> 5) & 1 ? v_high : v_low) : v_low, 0, trise);
	V(in2[5]) <+ transition(($abstime >= 31n + T_dur && $abstime < 31n + Twrite_dur) ?
                    ((row31_value_right >> 5) & 1 ? v_high : v_low) : v_low, 0, trise);
	V(in1[6]) <+ transition(($abstime >= 31n + T_dur && $abstime < 31n + Twrite_dur) ?
                    ((row31_value_left >> 6) & 1 ? v_high : v_low) : v_low, 0, trise);
	V(in2[6]) <+ transition(($abstime >= 31n + T_dur && $abstime < 31n + Twrite_dur) ?
                    ((row31_value_right >> 6) & 1 ? v_high : v_low) : v_low, 0, trise);
	V(in1[7]) <+ transition(($abstime >= 31n + T_dur && $abstime < 31n + Twrite_dur) ?
                    ((row31_value_left >> 7) & 1 ? v_high : v_low) : v_low, 0, trise);
	V(in2[7]) <+ transition(($abstime >= 31n + T_dur && $abstime < 31n + Twrite_dur) ?
                    ((row31_value_right >> 7) & 1 ? v_high : v_low) : v_low, 0, trise);
	V(in1[8]) <+ transition(($abstime >= 31n + T_dur && $abstime < 31n + Twrite_dur) ?
                    ((row31_value_left >> 8) & 1 ? v_high : v_low) : v_low, 0, trise);
	V(in2[8]) <+ transition(($abstime >= 31n + T_dur && $abstime < 31n + Twrite_dur) ?
                    ((row31_value_right >> 8) & 1 ? v_high : v_low) : v_low, 0, trise);
	V(in1[9]) <+ transition(($abstime >= 31n + T_dur && $abstime < 31n + Twrite_dur) ?
                    ((row31_value_left >> 9) & 1 ? v_high : v_low) : v_low, 0, trise);
	V(in2[9]) <+ transition(($abstime >= 31n + T_dur && $abstime < 31n + Twrite_dur) ?
                    ((row31_value_right >> 9) & 1 ? v_high : v_low) : v_low, 0, trise);
	V(in1[10]) <+ transition(($abstime >= 31n + T_dur && $abstime < 31n + Twrite_dur) ?
                    ((row31_value_left >> 10) & 1 ? v_high : v_low) : v_low, 0, trise);
	V(in2[10]) <+ transition(($abstime >= 31n + T_dur && $abstime < 31n + Twrite_dur) ?
                    ((row31_value_right >> 10) & 1 ? v_high : v_low) : v_low, 0, trise);
	V(in1[11]) <+ transition(($abstime >= 31n + T_dur && $abstime < 31n + Twrite_dur) ?
                    ((row31_value_left >> 11) & 1 ? v_high : v_low) : v_low, 0, trise);
	V(in2[11]) <+ transition(($abstime >= 31n + T_dur && $abstime < 31n + Twrite_dur) ?
                    ((row31_value_right >> 11) & 1 ? v_high : v_low) : v_low, 0, trise);
	V(in1[12]) <+ transition(($abstime >= 31n + T_dur && $abstime < 31n + Twrite_dur) ?
                    ((row31_value_left >> 12) & 1 ? v_high : v_low) : v_low, 0, trise);
	V(in2[12]) <+ transition(($abstime >= 31n + T_dur && $abstime < 31n + Twrite_dur) ?
                    ((row31_value_right >> 12) & 1 ? v_high : v_low) : v_low, 0, trise);
	V(in1[13]) <+ transition(($abstime >= 31n + T_dur && $abstime < 31n + Twrite_dur) ?
                    ((row31_value_left >> 13) & 1 ? v_high : v_low) : v_low, 0, trise);
	V(in2[13]) <+ transition(($abstime >= 31n + T_dur && $abstime < 31n + Twrite_dur) ?
                    ((row31_value_right >> 13) & 1 ? v_high : v_low) : v_low, 0, trise);
	V(in1[14]) <+ transition(($abstime >= 31n + T_dur && $abstime < 31n + Twrite_dur) ?
                    ((row31_value_left >> 14) & 1 ? v_high : v_low) : v_low, 0, trise);
	V(in2[14]) <+ transition(($abstime >= 31n + T_dur && $abstime < 31n + Twrite_dur) ?
                    ((row31_value_right >> 14) & 1 ? v_high : v_low) : v_low, 0, trise);
	V(in1[15]) <+ transition(($abstime >= 31n + T_dur && $abstime < 31n + Twrite_dur) ?
                    ((row31_value_left >> 15) & 1 ? v_high : v_low) : v_low, 0, trise);
	V(in2[15]) <+ transition(($abstime >= 31n + T_dur && $abstime < 31n + Twrite_dur) ?
                    ((row31_value_right >> 15) & 1 ? v_high : v_low) : v_low, 0, trise);
	V(in1[16]) <+ transition(($abstime >= 31n + T_dur && $abstime < 31n + Twrite_dur) ?
                    ((row31_value_left >> 16) & 1 ? v_high : v_low) : v_low, 0, trise);
	V(in2[16]) <+ transition(($abstime >= 31n + T_dur && $abstime < 31n + Twrite_dur) ?
                    ((row31_value_right >> 16) & 1 ? v_high : v_low) : v_low, 0, trise);
	V(in1[17]) <+ transition(($abstime >= 31n + T_dur && $abstime < 31n + Twrite_dur) ?
                    ((row31_value_left >> 17) & 1 ? v_high : v_low) : v_low, 0, trise);
	V(in2[17]) <+ transition(($abstime >= 31n + T_dur && $abstime < 31n + Twrite_dur) ?
                    ((row31_value_right >> 17) & 1 ? v_high : v_low) : v_low, 0, trise);
	V(in1[18]) <+ transition(($abstime >= 31n + T_dur && $abstime < 31n + Twrite_dur) ?
                    ((row31_value_left >> 18) & 1 ? v_high : v_low) : v_low, 0, trise);
	V(in2[18]) <+ transition(($abstime >= 31n + T_dur && $abstime < 31n + Twrite_dur) ?
                    ((row31_value_right >> 18) & 1 ? v_high : v_low) : v_low, 0, trise);
	V(in1[19]) <+ transition(($abstime >= 31n + T_dur && $abstime < 31n + Twrite_dur) ?
                    ((row31_value_left >> 19) & 1 ? v_high : v_low) : v_low, 0, trise);
	V(in2[19]) <+ transition(($abstime >= 31n + T_dur && $abstime < 31n + Twrite_dur) ?
                    ((row31_value_right >> 19) & 1 ? v_high : v_low) : v_low, 0, trise);
	V(in1[20]) <+ transition(($abstime >= 31n + T_dur && $abstime < 31n + Twrite_dur) ?
                    ((row31_value_left >> 20) & 1 ? v_high : v_low) : v_low, 0, trise);
	V(in2[20]) <+ transition(($abstime >= 31n + T_dur && $abstime < 31n + Twrite_dur) ?
                    ((row31_value_right >> 20) & 1 ? v_high : v_low) : v_low, 0, trise);
	V(in1[21]) <+ transition(($abstime >= 31n + T_dur && $abstime < 31n + Twrite_dur) ?
                    ((row31_value_left >> 21) & 1 ? v_high : v_low) : v_low, 0, trise);
	V(in2[21]) <+ transition(($abstime >= 31n + T_dur && $abstime < 31n + Twrite_dur) ?
                    ((row31_value_right >> 21) & 1 ? v_high : v_low) : v_low, 0, trise);
	V(in1[22]) <+ transition(($abstime >= 31n + T_dur && $abstime < 31n + Twrite_dur) ?
                    ((row31_value_left >> 22) & 1 ? v_high : v_low) : v_low, 0, trise);
	V(in2[22]) <+ transition(($abstime >= 31n + T_dur && $abstime < 31n + Twrite_dur) ?
                    ((row31_value_right >> 22) & 1 ? v_high : v_low) : v_low, 0, trise);
	V(in1[23]) <+ transition(($abstime >= 31n + T_dur && $abstime < 31n + Twrite_dur) ?
                    ((row31_value_left >> 23) & 1 ? v_high : v_low) : v_low, 0, trise);
	V(in2[23]) <+ transition(($abstime >= 31n + T_dur && $abstime < 31n + Twrite_dur) ?
                    ((row31_value_right >> 23) & 1 ? v_high : v_low) : v_low, 0, trise);
	V(in1[24]) <+ transition(($abstime >= 31n + T_dur && $abstime < 31n + Twrite_dur) ?
                    ((row31_value_left >> 24) & 1 ? v_high : v_low) : v_low, 0, trise);
	V(in2[24]) <+ transition(($abstime >= 31n + T_dur && $abstime < 31n + Twrite_dur) ?
                    ((row31_value_right >> 24) & 1 ? v_high : v_low) : v_low, 0, trise);
	V(in1[25]) <+ transition(($abstime >= 31n + T_dur && $abstime < 31n + Twrite_dur) ?
                    ((row31_value_left >> 25) & 1 ? v_high : v_low) : v_low, 0, trise);
	V(in2[25]) <+ transition(($abstime >= 31n + T_dur && $abstime < 31n + Twrite_dur) ?
                    ((row31_value_right >> 25) & 1 ? v_high : v_low) : v_low, 0, trise);
	V(in1[26]) <+ transition(($abstime >= 31n + T_dur && $abstime < 31n + Twrite_dur) ?
                    ((row31_value_left >> 26) & 1 ? v_high : v_low) : v_low, 0, trise);
	V(in2[26]) <+ transition(($abstime >= 31n + T_dur && $abstime < 31n + Twrite_dur) ?
                    ((row31_value_right >> 26) & 1 ? v_high : v_low) : v_low, 0, trise);
	V(in1[27]) <+ transition(($abstime >= 31n + T_dur && $abstime < 31n + Twrite_dur) ?
                    ((row31_value_left >> 27) & 1 ? v_high : v_low) : v_low, 0, trise);
	V(in2[27]) <+ transition(($abstime >= 31n + T_dur && $abstime < 31n + Twrite_dur) ?
                    ((row31_value_right >> 27) & 1 ? v_high : v_low) : v_low, 0, trise);
	V(in1[28]) <+ transition(($abstime >= 31n + T_dur && $abstime < 31n + Twrite_dur) ?
                    ((row31_value_left >> 28) & 1 ? v_high : v_low) : v_low, 0, trise);
	V(in2[28]) <+ transition(($abstime >= 31n + T_dur && $abstime < 31n + Twrite_dur) ?
                    ((row31_value_right >> 28) & 1 ? v_high : v_low) : v_low, 0, trise);
	V(in1[29]) <+ transition(($abstime >= 31n + T_dur && $abstime < 31n + Twrite_dur) ?
                    ((row31_value_left >> 29) & 1 ? v_high : v_low) : v_low, 0, trise);
	V(in2[29]) <+ transition(($abstime >= 31n + T_dur && $abstime < 31n + Twrite_dur) ?
                    ((row31_value_right >> 29) & 1 ? v_high : v_low) : v_low, 0, trise);
	V(in1[30]) <+ transition(($abstime >= 31n + T_dur && $abstime < 31n + Twrite_dur) ?
                    ((row31_value_left >> 30) & 1 ? v_high : v_low) : v_low, 0, trise);
	V(in2[30]) <+ transition(($abstime >= 31n + T_dur && $abstime < 31n + Twrite_dur) ?
                    ((row31_value_right >> 30) & 1 ? v_high : v_low) : v_low, 0, trise);
	V(in1[31]) <+ transition(($abstime >= 31n + T_dur && $abstime < 31n + Twrite_dur) ?
                    ((row31_value_left >> 31) & 1 ? v_high : v_low) : v_low, 0, trise);
	V(in2[31]) <+ transition(($abstime >= 31n + T_dur && $abstime < 31n + Twrite_dur) ?
                    ((row31_value_right >> 31) & 1 ? v_high : v_low) : v_low, 0, trise);

	// perML low right before SL
	V(preML[0]) <+ transition(($abstime >= Tsearch_start - TpreML_dur && $abstime < Tsearch_start) ?
                    v_low : v_high, 0, trise);
	V(preML[1]) <+ transition(($abstime >= Tsearch_start - TpreML_dur && $abstime < Tsearch_start) ?
                    v_low : v_high, 0, trise);
	V(preML[2]) <+ transition(($abstime >= Tsearch_start - TpreML_dur && $abstime < Tsearch_start) ?
                    v_low : v_high, 0, trise);
	V(preML[3]) <+ transition(($abstime >= Tsearch_start - TpreML_dur && $abstime < Tsearch_start) ?
                    v_low : v_high, 0, trise);
	V(preML[4]) <+ transition(($abstime >= Tsearch_start - TpreML_dur && $abstime < Tsearch_start) ?
                    v_low : v_high, 0, trise);
	V(preML[5]) <+ transition(($abstime >= Tsearch_start - TpreML_dur && $abstime < Tsearch_start) ?
                    v_low : v_high, 0, trise);
	V(preML[6]) <+ transition(($abstime >= Tsearch_start - TpreML_dur && $abstime < Tsearch_start) ?
                    v_low : v_high, 0, trise);
	V(preML[7]) <+ transition(($abstime >= Tsearch_start - TpreML_dur && $abstime < Tsearch_start) ?
                    v_low : v_high, 0, trise);
	V(preML[8]) <+ transition(($abstime >= Tsearch_start - TpreML_dur && $abstime < Tsearch_start) ?
                    v_low : v_high, 0, trise);
	V(preML[9]) <+ transition(($abstime >= Tsearch_start - TpreML_dur && $abstime < Tsearch_start) ?
                    v_low : v_high, 0, trise);
	V(preML[10]) <+ transition(($abstime >= Tsearch_start - TpreML_dur && $abstime < Tsearch_start) ?
                    v_low : v_high, 0, trise);
	V(preML[11]) <+ transition(($abstime >= Tsearch_start - TpreML_dur && $abstime < Tsearch_start) ?
                    v_low : v_high, 0, trise);
	V(preML[12]) <+ transition(($abstime >= Tsearch_start - TpreML_dur && $abstime < Tsearch_start) ?
                    v_low : v_high, 0, trise);
	V(preML[13]) <+ transition(($abstime >= Tsearch_start - TpreML_dur && $abstime < Tsearch_start) ?
                    v_low : v_high, 0, trise);
	V(preML[14]) <+ transition(($abstime >= Tsearch_start - TpreML_dur && $abstime < Tsearch_start) ?
                    v_low : v_high, 0, trise);
	V(preML[15]) <+ transition(($abstime >= Tsearch_start - TpreML_dur && $abstime < Tsearch_start) ?
                    v_low : v_high, 0, trise);
	V(preML[16]) <+ transition(($abstime >= Tsearch_start - TpreML_dur && $abstime < Tsearch_start) ?
                    v_low : v_high, 0, trise);
	V(preML[17]) <+ transition(($abstime >= Tsearch_start - TpreML_dur && $abstime < Tsearch_start) ?
                    v_low : v_high, 0, trise);
	V(preML[18]) <+ transition(($abstime >= Tsearch_start - TpreML_dur && $abstime < Tsearch_start) ?
                    v_low : v_high, 0, trise);
	V(preML[19]) <+ transition(($abstime >= Tsearch_start - TpreML_dur && $abstime < Tsearch_start) ?
                    v_low : v_high, 0, trise);
	V(preML[20]) <+ transition(($abstime >= Tsearch_start - TpreML_dur && $abstime < Tsearch_start) ?
                    v_low : v_high, 0, trise);
	V(preML[21]) <+ transition(($abstime >= Tsearch_start - TpreML_dur && $abstime < Tsearch_start) ?
                    v_low : v_high, 0, trise);
	V(preML[22]) <+ transition(($abstime >= Tsearch_start - TpreML_dur && $abstime < Tsearch_start) ?
                    v_low : v_high, 0, trise);
	V(preML[23]) <+ transition(($abstime >= Tsearch_start - TpreML_dur && $abstime < Tsearch_start) ?
                    v_low : v_high, 0, trise);
	V(preML[24]) <+ transition(($abstime >= Tsearch_start - TpreML_dur && $abstime < Tsearch_start) ?
                    v_low : v_high, 0, trise);
	V(preML[25]) <+ transition(($abstime >= Tsearch_start - TpreML_dur && $abstime < Tsearch_start) ?
                    v_low : v_high, 0, trise);
	V(preML[26]) <+ transition(($abstime >= Tsearch_start - TpreML_dur && $abstime < Tsearch_start) ?
                    v_low : v_high, 0, trise);
	V(preML[27]) <+ transition(($abstime >= Tsearch_start - TpreML_dur && $abstime < Tsearch_start) ?
                    v_low : v_high, 0, trise);
	V(preML[28]) <+ transition(($abstime >= Tsearch_start - TpreML_dur && $abstime < Tsearch_start) ?
                    v_low : v_high, 0, trise);
	V(preML[29]) <+ transition(($abstime >= Tsearch_start - TpreML_dur && $abstime < Tsearch_start) ?
                    v_low : v_high, 0, trise);
	V(preML[30]) <+ transition(($abstime >= Tsearch_start - TpreML_dur && $abstime < Tsearch_start) ?
                    v_low : v_high, 0, trise);
	V(preML[31]) <+ transition(($abstime >= Tsearch_start - TpreML_dur && $abstime < Tsearch_start) ?
                    v_low : v_high, 0, trise);

	// SL
	V(SL1[0]) <+ transition(($abstime >= Tsearch_start && $abstime < Tsearch_start + Tsearch_dur) ?
				((search_value_left >> 0) & 1 ? v_high : v_low) : v_low, 0, trise);
	V(SL2[0]) <+ transition(($abstime >= Tsearch_start && $abstime < Tsearch_start + Tsearch_dur) ?
				((search_value_right >> 0) & 1 ? v_high : v_low) : v_low, 0, trise);
	V(SL1[1]) <+ transition(($abstime >= Tsearch_start && $abstime < Tsearch_start + Tsearch_dur) ?
				((search_value_left >> 1) & 1 ? v_high : v_low) : v_low, 0, trise);
	V(SL2[1]) <+ transition(($abstime >= Tsearch_start && $abstime < Tsearch_start + Tsearch_dur) ?
				((search_value_right >> 1) & 1 ? v_high : v_low) : v_low, 0, trise);
	V(SL1[2]) <+ transition(($abstime >= Tsearch_start && $abstime < Tsearch_start + Tsearch_dur) ?
				((search_value_left >> 2) & 1 ? v_high : v_low) : v_low, 0, trise);
	V(SL2[2]) <+ transition(($abstime >= Tsearch_start && $abstime < Tsearch_start + Tsearch_dur) ?
				((search_value_right >> 2) & 1 ? v_high : v_low) : v_low, 0, trise);
	V(SL1[3]) <+ transition(($abstime >= Tsearch_start && $abstime < Tsearch_start + Tsearch_dur) ?
				((search_value_left >> 3) & 1 ? v_high : v_low) : v_low, 0, trise);
	V(SL2[3]) <+ transition(($abstime >= Tsearch_start && $abstime < Tsearch_start + Tsearch_dur) ?
				((search_value_right >> 3) & 1 ? v_high : v_low) : v_low, 0, trise);
	V(SL1[4]) <+ transition(($abstime >= Tsearch_start && $abstime < Tsearch_start + Tsearch_dur) ?
				((search_value_left >> 4) & 1 ? v_high : v_low) : v_low, 0, trise);
	V(SL2[4]) <+ transition(($abstime >= Tsearch_start && $abstime < Tsearch_start + Tsearch_dur) ?
				((search_value_right >> 4) & 1 ? v_high : v_low) : v_low, 0, trise);
	V(SL1[5]) <+ transition(($abstime >= Tsearch_start && $abstime < Tsearch_start + Tsearch_dur) ?
				((search_value_left >> 5) & 1 ? v_high : v_low) : v_low, 0, trise);
	V(SL2[5]) <+ transition(($abstime >= Tsearch_start && $abstime < Tsearch_start + Tsearch_dur) ?
				((search_value_right >> 5) & 1 ? v_high : v_low) : v_low, 0, trise);
	V(SL1[6]) <+ transition(($abstime >= Tsearch_start && $abstime < Tsearch_start + Tsearch_dur) ?
				((search_value_left >> 6) & 1 ? v_high : v_low) : v_low, 0, trise);
	V(SL2[6]) <+ transition(($abstime >= Tsearch_start && $abstime < Tsearch_start + Tsearch_dur) ?
				((search_value_right >> 6) & 1 ? v_high : v_low) : v_low, 0, trise);
	V(SL1[7]) <+ transition(($abstime >= Tsearch_start && $abstime < Tsearch_start + Tsearch_dur) ?
				((search_value_left >> 7) & 1 ? v_high : v_low) : v_low, 0, trise);
	V(SL2[7]) <+ transition(($abstime >= Tsearch_start && $abstime < Tsearch_start + Tsearch_dur) ?
				((search_value_right >> 7) & 1 ? v_high : v_low) : v_low, 0, trise);
	V(SL1[8]) <+ transition(($abstime >= Tsearch_start && $abstime < Tsearch_start + Tsearch_dur) ?
				((search_value_left >> 8) & 1 ? v_high : v_low) : v_low, 0, trise);
	V(SL2[8]) <+ transition(($abstime >= Tsearch_start && $abstime < Tsearch_start + Tsearch_dur) ?
				((search_value_right >> 8) & 1 ? v_high : v_low) : v_low, 0, trise);
	V(SL1[9]) <+ transition(($abstime >= Tsearch_start && $abstime < Tsearch_start + Tsearch_dur) ?
				((search_value_left >> 9) & 1 ? v_high : v_low) : v_low, 0, trise);
	V(SL2[9]) <+ transition(($abstime >= Tsearch_start && $abstime < Tsearch_start + Tsearch_dur) ?
				((search_value_right >> 9) & 1 ? v_high : v_low) : v_low, 0, trise);
	V(SL1[10]) <+ transition(($abstime >= Tsearch_start && $abstime < Tsearch_start + Tsearch_dur) ?
				((search_value_left >> 10) & 1 ? v_high : v_low) : v_low, 0, trise);
	V(SL2[10]) <+ transition(($abstime >= Tsearch_start && $abstime < Tsearch_start + Tsearch_dur) ?
				((search_value_right >> 10) & 1 ? v_high : v_low) : v_low, 0, trise);
	V(SL1[11]) <+ transition(($abstime >= Tsearch_start && $abstime < Tsearch_start + Tsearch_dur) ?
				((search_value_left >> 11) & 1 ? v_high : v_low) : v_low, 0, trise);
	V(SL2[11]) <+ transition(($abstime >= Tsearch_start && $abstime < Tsearch_start + Tsearch_dur) ?
				((search_value_right >> 11) & 1 ? v_high : v_low) : v_low, 0, trise);
	V(SL1[12]) <+ transition(($abstime >= Tsearch_start && $abstime < Tsearch_start + Tsearch_dur) ?
				((search_value_left >> 12) & 1 ? v_high : v_low) : v_low, 0, trise);
	V(SL2[12]) <+ transition(($abstime >= Tsearch_start && $abstime < Tsearch_start + Tsearch_dur) ?
				((search_value_right >> 12) & 1 ? v_high : v_low) : v_low, 0, trise);
	V(SL1[13]) <+ transition(($abstime >= Tsearch_start && $abstime < Tsearch_start + Tsearch_dur) ?
				((search_value_left >> 13) & 1 ? v_high : v_low) : v_low, 0, trise);
	V(SL2[13]) <+ transition(($abstime >= Tsearch_start && $abstime < Tsearch_start + Tsearch_dur) ?
				((search_value_right >> 13) & 1 ? v_high : v_low) : v_low, 0, trise);
	V(SL1[14]) <+ transition(($abstime >= Tsearch_start && $abstime < Tsearch_start + Tsearch_dur) ?
				((search_value_left >> 14) & 1 ? v_high : v_low) : v_low, 0, trise);
	V(SL2[14]) <+ transition(($abstime >= Tsearch_start && $abstime < Tsearch_start + Tsearch_dur) ?
				((search_value_right >> 14) & 1 ? v_high : v_low) : v_low, 0, trise);
	V(SL1[15]) <+ transition(($abstime >= Tsearch_start && $abstime < Tsearch_start + Tsearch_dur) ?
				((search_value_left >> 15) & 1 ? v_high : v_low) : v_low, 0, trise);
	V(SL2[15]) <+ transition(($abstime >= Tsearch_start && $abstime < Tsearch_start + Tsearch_dur) ?
				((search_value_right >> 15) & 1 ? v_high : v_low) : v_low, 0, trise);
	V(SL1[16]) <+ transition(($abstime >= Tsearch_start && $abstime < Tsearch_start + Tsearch_dur) ?
				((search_value_left >> 16) & 1 ? v_high : v_low) : v_low, 0, trise);
	V(SL2[16]) <+ transition(($abstime >= Tsearch_start && $abstime < Tsearch_start + Tsearch_dur) ?
				((search_value_right >> 16) & 1 ? v_high : v_low) : v_low, 0, trise);
	V(SL1[17]) <+ transition(($abstime >= Tsearch_start && $abstime < Tsearch_start + Tsearch_dur) ?
				((search_value_left >> 17) & 1 ? v_high : v_low) : v_low, 0, trise);
	V(SL2[17]) <+ transition(($abstime >= Tsearch_start && $abstime < Tsearch_start + Tsearch_dur) ?
				((search_value_right >> 17) & 1 ? v_high : v_low) : v_low, 0, trise);
	V(SL1[18]) <+ transition(($abstime >= Tsearch_start && $abstime < Tsearch_start + Tsearch_dur) ?
				((search_value_left >> 18) & 1 ? v_high : v_low) : v_low, 0, trise);
	V(SL2[18]) <+ transition(($abstime >= Tsearch_start && $abstime < Tsearch_start + Tsearch_dur) ?
				((search_value_right >> 18) & 1 ? v_high : v_low) : v_low, 0, trise);
	V(SL1[19]) <+ transition(($abstime >= Tsearch_start && $abstime < Tsearch_start + Tsearch_dur) ?
				((search_value_left >> 19) & 1 ? v_high : v_low) : v_low, 0, trise);
	V(SL2[19]) <+ transition(($abstime >= Tsearch_start && $abstime < Tsearch_start + Tsearch_dur) ?
				((search_value_right >> 19) & 1 ? v_high : v_low) : v_low, 0, trise);
	V(SL1[20]) <+ transition(($abstime >= Tsearch_start && $abstime < Tsearch_start + Tsearch_dur) ?
				((search_value_left >> 20) & 1 ? v_high : v_low) : v_low, 0, trise);
	V(SL2[20]) <+ transition(($abstime >= Tsearch_start && $abstime < Tsearch_start + Tsearch_dur) ?
				((search_value_right >> 20) & 1 ? v_high : v_low) : v_low, 0, trise);
	V(SL1[21]) <+ transition(($abstime >= Tsearch_start && $abstime < Tsearch_start + Tsearch_dur) ?
				((search_value_left >> 21) & 1 ? v_high : v_low) : v_low, 0, trise);
	V(SL2[21]) <+ transition(($abstime >= Tsearch_start && $abstime < Tsearch_start + Tsearch_dur) ?
				((search_value_right >> 21) & 1 ? v_high : v_low) : v_low, 0, trise);
	V(SL1[22]) <+ transition(($abstime >= Tsearch_start && $abstime < Tsearch_start + Tsearch_dur) ?
				((search_value_left >> 22) & 1 ? v_high : v_low) : v_low, 0, trise);
	V(SL2[22]) <+ transition(($abstime >= Tsearch_start && $abstime < Tsearch_start + Tsearch_dur) ?
				((search_value_right >> 22) & 1 ? v_high : v_low) : v_low, 0, trise);
	V(SL1[23]) <+ transition(($abstime >= Tsearch_start && $abstime < Tsearch_start + Tsearch_dur) ?
				((search_value_left >> 23) & 1 ? v_high : v_low) : v_low, 0, trise);
	V(SL2[23]) <+ transition(($abstime >= Tsearch_start && $abstime < Tsearch_start + Tsearch_dur) ?
				((search_value_right >> 23) & 1 ? v_high : v_low) : v_low, 0, trise);
	V(SL1[24]) <+ transition(($abstime >= Tsearch_start && $abstime < Tsearch_start + Tsearch_dur) ?
				((search_value_left >> 24) & 1 ? v_high : v_low) : v_low, 0, trise);
	V(SL2[24]) <+ transition(($abstime >= Tsearch_start && $abstime < Tsearch_start + Tsearch_dur) ?
				((search_value_right >> 24) & 1 ? v_high : v_low) : v_low, 0, trise);
	V(SL1[25]) <+ transition(($abstime >= Tsearch_start && $abstime < Tsearch_start + Tsearch_dur) ?
				((search_value_left >> 25) & 1 ? v_high : v_low) : v_low, 0, trise);
	V(SL2[25]) <+ transition(($abstime >= Tsearch_start && $abstime < Tsearch_start + Tsearch_dur) ?
				((search_value_right >> 25) & 1 ? v_high : v_low) : v_low, 0, trise);
	V(SL1[26]) <+ transition(($abstime >= Tsearch_start && $abstime < Tsearch_start + Tsearch_dur) ?
				((search_value_left >> 26) & 1 ? v_high : v_low) : v_low, 0, trise);
	V(SL2[26]) <+ transition(($abstime >= Tsearch_start && $abstime < Tsearch_start + Tsearch_dur) ?
				((search_value_right >> 26) & 1 ? v_high : v_low) : v_low, 0, trise);
	V(SL1[27]) <+ transition(($abstime >= Tsearch_start && $abstime < Tsearch_start + Tsearch_dur) ?
				((search_value_left >> 27) & 1 ? v_high : v_low) : v_low, 0, trise);
	V(SL2[27]) <+ transition(($abstime >= Tsearch_start && $abstime < Tsearch_start + Tsearch_dur) ?
				((search_value_right >> 27) & 1 ? v_high : v_low) : v_low, 0, trise);
	V(SL1[28]) <+ transition(($abstime >= Tsearch_start && $abstime < Tsearch_start + Tsearch_dur) ?
				((search_value_left >> 28) & 1 ? v_high : v_low) : v_low, 0, trise);
	V(SL2[28]) <+ transition(($abstime >= Tsearch_start && $abstime < Tsearch_start + Tsearch_dur) ?
				((search_value_right >> 28) & 1 ? v_high : v_low) : v_low, 0, trise);
	V(SL1[29]) <+ transition(($abstime >= Tsearch_start && $abstime < Tsearch_start + Tsearch_dur) ?
				((search_value_left >> 29) & 1 ? v_high : v_low) : v_low, 0, trise);
	V(SL2[29]) <+ transition(($abstime >= Tsearch_start && $abstime < Tsearch_start + Tsearch_dur) ?
				((search_value_right >> 29) & 1 ? v_high : v_low) : v_low, 0, trise);
	V(SL1[30]) <+ transition(($abstime >= Tsearch_start && $abstime < Tsearch_start + Tsearch_dur) ?
				((search_value_left >> 30) & 1 ? v_high : v_low) : v_low, 0, trise);
	V(SL2[30]) <+ transition(($abstime >= Tsearch_start && $abstime < Tsearch_start + Tsearch_dur) ?
				((search_value_right >> 30) & 1 ? v_high : v_low) : v_low, 0, trise);
	V(SL1[31]) <+ transition(($abstime >= Tsearch_start && $abstime < Tsearch_start + Tsearch_dur) ?
				((search_value_left >> 31) & 1 ? v_high : v_low) : v_low, 0, trise);
	V(SL2[31]) <+ transition(($abstime >= Tsearch_start && $abstime < Tsearch_start + Tsearch_dur) ?
				((search_value_right >> 31) & 1 ? v_high : v_low) : v_low, 0, trise);
  end
endmodule
