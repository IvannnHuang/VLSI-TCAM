ADE simulation setup
Run mode: Single Run, Sweeps and Corners
Tests:
  ECE4740_Final_TCAM_array_tb_1: ECE4740_Final_TCAM/array_tb/config, simulator spectre
    Variables: vdd = 1
    Outputs: "/pre"; "/preW"; /write; /preW; /SL1<31:0>; /SL2<31:0>; /in1<31:0>; /WL<31:0>; /Match_Addr<4:0>
