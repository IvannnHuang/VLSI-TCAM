ADE simulation setup
Test ECE4740_Final_TCAM_array_tb_1: ECE4740_Final_TCAM/array_tb/config, simulator spectre
  Models: /opt/cadence-designkits/gpdk045_v_6_0/gpdk045/../models/spectre/gpdk045.scs[mc]
  Variables: vdd = 1
  Temperature: 27
  Analysis tran: stop=40n
  Signals: /preW, /write, /SL1<31:0>, /SL2<31:0>, /in1<31:0>, /in2<31:0>, /WL<31:0>, /ML_out<31:0>, /preML<31:0>, /Match_Addr<4:0>, /BL1<31:0>, /BL1c<31:0>, /BL2<31:0>, /BL2c<31:0>, /pwr_mon
Run mode: Single Run, Sweeps and Corners
