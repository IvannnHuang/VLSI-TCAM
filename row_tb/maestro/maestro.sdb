ADE simulation setup
Run mode: Single Run, Sweeps and Corners
Tests:
  ECE4740_Final_TCAM_row_tb_1: ECE4740_Final_TCAM/row_tb/config, simulator spectre
    Variables: vdd = 1
    Outputs: "/in<31:0>"; "/in1<31:0>"; /in2<31:0>; /in1<31:0>; /BL1<31:0>; /BL1c<31:0>; /BL2<31:0>; /BL2c<31:0>; /pre; /write; /WL; /ML; /ML_out; /SL1<31:0>; /SL2<31:0>
