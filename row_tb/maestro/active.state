ADE simulation setup
Test ECE4740_Final_TCAM_row_tb_1: ECE4740_Final_TCAM/row_tb/config, simulator spectre
  Models: /opt/cadence-designkits/gpdk045_v_6_0/gpdk045/../models/spectre/gpdk045.scs[mc]
  Variables: vdd = 1
  Temperature: 27
  Analysis tran: stop=2n
  Signals: /in1<31:0>, /in2<31:0>, /pre, /BL1<31:0>, /BL1c<31:0>, /BL2<31:0>, /BL2c<31:0>, /write, /WL, /ML_out, /SL1<31:0>, /SL2<31:0>
Run mode: Single Run, Sweeps and Corners
