ADE simulation setup
Run mode: Single Run, Sweeps and Corners
Tests:
  ECE4740_Final_TCAM_encode_tb_1: ECE4740_Final_TCAM/encode_tb/schematic, simulator spectre
    Variables: Tper = 2n; vdd = 1; Tena = 0.4n; Tclk = Tper
