ADE simulation setup
Test ECE4740_Final_TCAM_encode_tb_1: ECE4740_Final_TCAM/encode_tb/schematic, simulator spectre
  Models: /opt/cadence-designkits/gpdk045_v_6_0/gpdk045/../models/spectre/gpdk045.scs[mc]
  Variables: Tper = 2n; vdd = 1; Tena = 0.4n; Tclk = Tper
  Temperature: 27
  Analysis tran: stop=32*VAR("Tper") errpreset=conservative
  Signals: /ena, /A<31:0>, /out<4:0>
Run mode: Single Run, Sweeps and Corners
