ADE simulation setup
Test ECE4740_S25_inv_1_1: ECE4740_S25/inv_1/schematic, simulator spectre
  Models: /opt/cadence-designkits/gpdk045_v_6_0/gpdk045/../models/spectre/gpdk045.scs[mc]
  Variables: voff = 0
  Temperature: 27
  Simulator options: tnom=25
  Analysis dc: sweep voff start=0 stop=1 step=10m (saves the operating point)
  Analysis tran: stop=3n errpreset=conservative
