ADE simulation setup
Test ECE4740_Final_TCAM_tcam_cell_tb_1: ECE4740_Final_TCAM/tcam_cell_tb/schematic, simulator spectre
  Models: /opt/cadence-designkits/gpdk045_v_6_0/gpdk045/../models/spectre/gpdk045.scs[mc]
  Variables: vdd = 1
  Temperature: 27
  Analysis tran: stop=2.5n errpreset=moderate
  Signals: /in1, /in2, /pre, /write, /WL, /BL1, /BL1c, /BL2, /BL2c, /ML, /ML_out, /SL1, /SL2
Run mode: Single Run, Sweeps and Corners
