ADE simulation setup
Run mode: Single Run, Sweeps and Corners
Tests:
  ECE4740_Final_TCAM_tcam_cell_tb_1: ECE4740_Final_TCAM/tcam_cell_tb/schematic, simulator spectre
    Variables: vdd = 1
    Outputs: /in1; /in2; nil; /pre; /write; /BL1; /BL1c; /BL2; /BL2c; /ML; /WL; /ML_out; /SL1; /SL2
